* NGSPICE file created from sg13cmos5l_yacinesot_ip__diff_opamp_cmfb.ext - technology: ihp-sg13cmos5l

.subckt sg13cmos5l_yacinesot_ip__diff_opamp_cmfb s5_an[1] analog_bus0 analog_bus1
+ ibias0 enable s5_an[2] s5_an[0] vdd_1v2 vss_1v2
X0 vss_1v2.t208 vss_1v2.t205 vss_1v2.t207 vss_1v2.t206 sg13_lv_nmos ad=0.133p pd=1.08u as=0 ps=0 w=0.7u l=0.5u
X1 vss_1v2.t12 vss_1v2.t12 vss_1v2.t12 vss_1v2.t274 sg13_lv_nmos ad=95f pd=0.88u as=0 ps=0 w=0.5u l=0.5u
X2 ota_cmfb_top_0.ota_cmfb_core_push_pull_output_stage_0/dynamic_pcell$4_0.DRN_NET_HI ota_cmfb_top_0.dynamic_pcell$5_0.F_DRN vdd_1v2.t450 vdd_1v2.t0 sg13_lv_pmos ad=0.475p pd=2.88u as=0.85p ps=5.68u w=2.5u l=3u
X3 ota_cmfb_top_0.ota_cmfb_core_push_pull_output_stage_1/dynamic_pcell$4_0.SRC_NET_IJ_GATE_DI ota_cmfb_top_0.ota_cmfb_core_push_pull_output_stage_1/dynamic_pcell$4_0.SRC_NET_IJ_GATE_DI ota_cmfb_top_0.ota_cmfb_core_push_pull_output_stage_1/dynamic_pcell$4_0.DRN_NET_HI vdd_1v2.t0 sg13_lv_pmos ad=0.475p pd=2.88u as=0.475p ps=2.88u w=2.5u l=3u
X4 vss_1v2.t242 vss_1v2.t240 vss_1v2.t241 vss_1v2.t202 sg13_lv_nmos ad=0.238p pd=2.08u as=0 ps=0 w=0.7u l=0.5u
X5 vdd_1v2.t318 vdd_1v2.t316 vdd_1v2.t317 vdd_1v2.t0 sg13_lv_pmos ad=0.85p pd=5.68u as=0 ps=0 w=2.5u l=0.5u
X6 vdd_1v2.t411 enable.t4 ota_cmfb_top_0.EN_INV_0/sg13cmos5l_inv_4_0.Y vdd_1v2.t0 sg13_lv_pmos ad=0.3808p pd=2.92u as=0.2128p ps=1.5u w=1.12u l=0.13u
X7 ota_cmfb_top_0.ota_cmfb_core_push_pull_output_stage_0/dynamic_pcell$4_0.B_DRN ota_cmfb_top_0.ota_cmfb_core_push_pull_output_stage_0/dynamic_pcell$4_0.B_DRN ota_cmfb_top_0.ota_cmfb_core_push_pull_output_stage_0/dynamic_pcell$4_0.DRN_NET_OP_GATE_MP vss_1v2.t0 sg13_lv_nmos ad=0.133p pd=1.08u as=0.133p ps=1.08u w=0.7u l=3u
X8 ota_cmfb_top_0.ota_cmfb_core_push_pull_output_stage_0/dynamic_pcell$4_0.DRN_NET_MENX ota_cmfb_top_0.ota_cmfb_core_push_pull_output_stage_0/dynamic_pcell$4_0.B_DRN ota_cmfb_top_0.dynamic_pcell$5_0.DRN_NET_BD vss_1v2.t3 sg13_lv_nmos ad=0.133p pd=1.08u as=0.133p ps=1.08u w=0.7u l=3u
X9 vss_1v2.t134 ota_cmfb_top_0.dynamic_pcell$5_0.DRN_NET_E_GATE_CDEFGH ota_cmfb_top_0.dynamic_pcell$5_0.DRN_NET_CA vss_1v2.t318 sg13_lv_nmos ad=62.5f pd=0.74u as=62.5f ps=0.74u w=0.25u l=10u
X10 vss_1v2.t163 vss_1v2.t161 vss_1v2.t162 vss_1v2.t149 sg13_lv_nmos ad=0.238p pd=2.08u as=0 ps=0 w=0.7u l=0.5u
X11 a_50660_27418# a_50924_27132# vss_1v2.t35 rhigh l=1u w=0.5u
X12 ota_cmfb_top_0.dynamic_pcell$5_0.DRN_NET_CA ota_cmfb_top_0.ota_cmfb_core_push_pull_output_stage_1/dynamic_pcell$4_0.SRC_NET_IJ_GATE_DI ota_cmfb_top_0.ota_cmfb_core_push_pull_output_stage_1/dynamic_pcell$4_0.DRN_NET_CD vdd_1v2.t0 sg13_lv_pmos ad=0.475p pd=2.88u as=0.85p ps=5.68u w=2.5u l=3u
X13 vdd_1v2.t91 vdd_1v2.t89 vdd_1v2.t90 vdd_1v2.t0 sg13_lv_pmos ad=0.425p pd=3.18u as=0 ps=0 w=1.25u l=0.5u
X14 ota_cmfb_top_0.dynamic_pcell$5_0.DRN_NET_BD ota_cmfb_top_0.ota_cmfb_core_push_pull_output_stage_0/dynamic_pcell$4_0.SRC_NET_IJ_GATE_DI ota_cmfb_top_0.ota_cmfb_core_push_pull_output_stage_0/dynamic_pcell$4_0.DRN_NET_CD vdd_1v2.t0 sg13_lv_pmos ad=0.475p pd=2.88u as=0.85p ps=5.68u w=2.5u l=3u
X15 vss_1v2.t87 ota_cmfb_top_0.dynamic_pcell$5_0.DRN_NET_E_GATE_CDEFGH ota_cmfb_top_0.dynamic_pcell$5_0.DRN_NET_BD vss_1v2.t318 sg13_lv_nmos ad=62.5f pd=0.74u as=62.5f ps=0.74u w=0.25u l=10u
X16 a_50924_27979# s5_an[2] vss_1v2.t10 rhigh l=1u w=0.5u
X17 a_58402_34440# a_58402_33917# vss_1v2.t43 rhigh l=1u w=0.5u
X18 vss_1v2.t171 vss_1v2.t170 ota_cmfb_top_0.ota_cmfb_core_push_pull_output_stage_1/dynamic_pcell$4_0.DRN_NET_MENX vss_1v2.t27 sg13_lv_nmos ad=0.133p pd=1.08u as=0.133p ps=1.08u w=0.7u l=3u
X19 vdd_1v2.t330 vdd_1v2.t341 ota_cmfb_top_0.ota_cmfb_core_push_pull_output_stage_0/dynamic_pcell$4_0.DRN_NET_CD vdd_1v2.t0 sg13_lv_pmos ad=0.475p pd=2.88u as=0.475p ps=2.88u w=2.5u l=0.5u
X20 ota_cmfb_top_0.ota_cmfb_core_push_pull_output_stage_0/dynamic_pcell$4_0.DRN_NET_OP_GATE_MP ota_cmfb_top_0.ota_cmfb_core_push_pull_output_stage_0/dynamic_pcell$4_0.DRN_NET_OP_GATE_MP ota_cmfb_top_0.ota_cmfb_core_push_pull_output_stage_0/dynamic_pcell$4_0.Gate vss_1v2.t1 sg13_lv_nmos ad=0.133p pd=1.08u as=0.133p ps=1.08u w=0.7u l=3u
X21 ota_cmfb_top_0.ota_cmfb_core_push_pull_output_stage_1/dynamic_pcell$4_0.DRN_NET_HI ota_cmfb_top_0.ota_cmfb_core_push_pull_output_stage_1/dynamic_pcell$4_0.SRC_NET_IJ_GATE_DI ota_cmfb_top_0.ota_cmfb_core_push_pull_output_stage_1/dynamic_pcell$4_0.SRC_NET_IJ_GATE_DI vdd_1v2.t0 sg13_lv_pmos ad=0.475p pd=2.88u as=0.475p ps=2.88u w=2.5u l=3u
X22 vdd_1v2.t458 ota_cmfb_top_0.dynamic_pcell$5_0.H_DRN ota_cmfb_top_0.dynamic_pcell$5_0.SRC_NET_KL.t6 vdd_1v2.t0 sg13_lv_pmos ad=0.2375p pd=1.63u as=0.2375p ps=1.63u w=1.25u l=5u
X23 ota_cmfb_top_0.ota_cmfb_core_push_pull_output_stage_0/dynamic_pcell$4_0.DRN_NET_HI ota_cmfb_top_0.ota_cmfb_core_push_pull_output_stage_0/dynamic_pcell$4_0.SRC_NET_IJ_GATE_DI ota_cmfb_top_0.ota_cmfb_core_push_pull_output_stage_0/dynamic_pcell$4_0.SRC_NET_IJ_GATE_DI vdd_1v2.t0 sg13_lv_pmos ad=0.475p pd=2.88u as=0.475p ps=2.88u w=2.5u l=3u
X24 vss_1v2.t286 vss_1v2.t284 vss_1v2.t286 vss_1v2.t291 sg13_lv_nmos ad=95f pd=0.88u as=0 ps=0 w=0.5u l=0.5u
X25 vdd_1v2.t106 vdd_1v2.t113 vdd_1v2.t103 vdd_1v2.t0 sg13_lv_pmos ad=0.2375p pd=1.63u as=0 ps=0 w=1.25u l=0.5u
X26 ota_cmfb_top_0.dynamic_pcell$5_0.DRN_NET_BD enable.t7 vdd_1v2.t408 vdd_1v2.t0 sg13_lv_pmos ad=0.1005p pd=1.34u as=0.1005p ps=1.34u w=0.15u l=0.13u
X27 ota_cmfb_top_0.ota_cmfb_core_push_pull_output_stage_1/dynamic_pcell$4_0.DRN_NET_OP_GATE_MP ota_cmfb_top_0.ota_cmfb_core_push_pull_output_stage_1/dynamic_pcell$4_0.DRN_NET_OP_GATE_MP ota_cmfb_top_0.ota_cmfb_core_push_pull_output_stage_1/dynamic_pcell$4_0.Gate vss_1v2.t21 sg13_lv_nmos ad=0.133p pd=1.08u as=0.133p ps=1.08u w=0.7u l=3u
X28 vdd_1v2.t464 ota_cmfb_top_0.dynamic_pcell$5_0.DRN_NET_BD s5_an[2] vdd_1v2.t0 sg13_lv_pmos ad=95f pd=0.88u as=95f ps=0.88u w=0.5u l=0.5u
X29 vss_1v2.t125 vss_1v2.t124 ota_cmfb_top_0.dynamic_pcell$5_0.G_DRN.t2 vss_1v2.t73 sg13_lv_nmos ad=62.5f pd=0.74u as=62.5f ps=0.74u w=0.25u l=0.5u
X30 ota_cmfb_top_0.dynamic_pcell$5_0.G_DRN.t4 ota_cmfb_top_0.dynamic_pcell$5_0.G_DRN vdd_1v2.t8 vdd_1v2.t0 sg13_lv_pmos ad=0.475p pd=2.88u as=0.475p ps=2.88u w=2.5u l=3u
X31 vss_1v2.t246 vss_1v2.t246 vss_1v2.t246 vss_1v2.t266 sg13_lv_nmos ad=95f pd=0.88u as=0 ps=0 w=0.5u l=0.5u
X32 vss_1v2.t12 vss_1v2.t12 vss_1v2.t12 vss_1v2.t101 sg13_lv_nmos ad=95f pd=0.88u as=0 ps=0 w=0.5u l=0.5u
X33 ota_cmfb_top_0.dynamic_pcell$5_0.F_DRN.t5 ota_cmfb_top_0.dynamic_pcell$5_0.F_DRN vdd_1v2.t435 vdd_1v2.t0 sg13_lv_pmos ad=0.475p pd=2.88u as=0.475p ps=2.88u w=2.5u l=3u
X34 a_49868_27979# a_50132_27693# vss_1v2.t10 rhigh l=1u w=0.5u
X35 vss_1v2.t232 vss_1v2.t231 ota_cmfb_top_0.ota_cmfb_core_push_pull_output_stage_0/dynamic_pcell$4_0.DRN_NET_MENX vss_1v2.t0 sg13_lv_nmos ad=0.133p pd=1.08u as=0.133p ps=1.08u w=0.7u l=3u
X36 vss_1v2.t349 ota_cmfb_top_0.ota_cmfb_core_push_pull_output_stage_0/dynamic_pcell$4_0.Gate ota_cmfb_top_0.ota_cmfb_core_push_pull_output_stage_0/dynamic_pcell$4_0.Gate vss_1v2.t3 sg13_lv_nmos ad=0.133p pd=1.08u as=0.133p ps=1.08u w=0.7u l=3u
X37 ota_cmfb_top_0.ota_cmfb_core_push_pull_output_stage_1/dynamic_pcell$4_0.B_DRN ota_cmfb_top_0.dynamic_pcell$5_0.G_DRN vdd_1v2.t1 vdd_1v2.t0 sg13_lv_pmos ad=0.475p pd=2.88u as=0.475p ps=2.88u w=2.5u l=3u
X38 ota_cmfb_top_0.dynamic_pcell$5_0.Gate ota_cmfb_top_0.dynamic_pcell$5_0.Gate vss_1v2.t320 vss_1v2.t317 sg13_lv_nmos ad=62.5f pd=0.74u as=62.5f ps=0.74u w=0.25u l=10u
X39 vss_1v2.t18 vss_1v2.t297 vss_1v2.t18 vss_1v2.t210 sg13_lv_nmos ad=95f pd=0.88u as=0 ps=0 w=0.5u l=0.5u
X40 vdd_1v2.t414 enable.t3 ota_cmfb_top_0.EN_INV_1/sg13cmos5l_inv_4_0.Y vdd_1v2.t0 sg13_lv_pmos ad=0.3808p pd=2.92u as=0.2128p ps=1.5u w=1.12u l=0.13u
X41 vss_1v2.t181 vss_1v2.t179 vss_1v2.t180 vss_1v2.t149 sg13_lv_nmos ad=0.238p pd=2.08u as=0 ps=0 w=0.7u l=0.5u
X42 ota_cmfb_top_0.ota_cmfb_core_push_pull_output_stage_1/dynamic_pcell$4_0.DRN_NET_MENX ota_cmfb_top_0.ota_cmfb_core_push_pull_output_stage_1/dynamic_pcell$4_0.DRN_NET_OP_GATE_MP ota_cmfb_top_0.ota_cmfb_core_push_pull_output_stage_1/dynamic_pcell$4_0.SRC_NET_ML vss_1v2.t22 sg13_lv_nmos ad=0.133p pd=1.08u as=0.133p ps=1.08u w=0.7u l=3u
X43 vdd_1v2.t340 vdd_1v2.t338 vdd_1v2.t339 vdd_1v2.t0 sg13_lv_pmos ad=0.475p pd=2.88u as=0 ps=0 w=2.5u l=0.5u
X44 vss_1v2.t34 ota_cmfb_top_0.dynamic_pcell$5_0.DRN_NET_E_GATE_CDEFGH ota_cmfb_top_0.dynamic_pcell$5_0.DRN_NET_CA vss_1v2.t317 sg13_lv_nmos ad=62.5f pd=0.74u as=62.5f ps=0.74u w=0.25u l=10u
X45 vdd_1v2.t371 vdd_1v2.t381 ota_cmfb_top_0.dynamic_pcell$5_0.DRN_NET_BD vdd_1v2.t0 sg13_lv_pmos ad=0.475p pd=2.88u as=0.475p ps=2.88u w=2.5u l=0.5u
X46 s5_an[1] a_50924_27132# vss_1v2.t363 rhigh l=1u w=0.5u
X47 ota_cmfb_top_0.ota_cmfb_core_push_pull_output_stage_1/dynamic_pcell$4_0.DRN_NET_HI ota_cmfb_top_0.ota_cmfb_core_push_pull_output_stage_1/dynamic_pcell$4_0.SRC_NET_IJ_GATE_DI ota_cmfb_top_0.ota_cmfb_core_push_pull_output_stage_1/dynamic_pcell$4_0.SRC_NET_IJ_GATE_DI vdd_1v2.t0 sg13_lv_pmos ad=0.475p pd=2.88u as=0.85p ps=5.68u w=2.5u l=3u
X48 ota_cmfb_top_0.dynamic_pcell$5_0.F_DRN.t3 enable.t6 vdd_1v2.t407 vdd_1v2.t0 sg13_lv_pmos ad=0.1005p pd=1.34u as=0.1005p ps=1.34u w=0.15u l=0.13u
X49 ota_cmfb_top_0.ota_cmfb_core_push_pull_output_stage_1/dynamic_pcell$4_0.Gate ota_cmfb_top_0.ota_cmfb_core_push_pull_output_stage_1/dynamic_pcell$4_0.Gate vss_1v2.t20 vss_1v2.t27 sg13_lv_nmos ad=0.133p pd=1.08u as=0.133p ps=1.08u w=0.7u l=3u
X50 ota_cmfb_top_0.ota_cmfb_core_push_pull_output_stage_0/dynamic_pcell$4_0.DRN_NET_OP_GATE_MP vss_1v2.t219 vss_1v2.t218 vss_1v2.t196 sg13_lv_nmos ad=0.133p pd=1.08u as=0.133p ps=1.08u w=0.7u l=0.5u
X51 ota_cmfb_top_0.ota_cmfb_core_push_pull_output_stage_0/dynamic_pcell$4_0.DRN_NET_HI ota_cmfb_top_0.ota_cmfb_core_push_pull_output_stage_0/dynamic_pcell$4_0.SRC_NET_IJ_GATE_DI ota_cmfb_top_0.ota_cmfb_core_push_pull_output_stage_0/dynamic_pcell$4_0.SRC_NET_IJ_GATE_DI vdd_1v2.t0 sg13_lv_pmos ad=0.475p pd=2.88u as=0.85p ps=5.68u w=2.5u l=3u
X52 vss_1v2.t138 vss_1v2.t140 vss_1v2.t132 vss_1v2.t70 sg13_lv_nmos ad=62.5f pd=0.74u as=0 ps=0 w=0.25u l=0.5u
X53 vdd_1v2.t262 vdd_1v2.t258 vdd_1v2.t264 vdd_1v2.t0 sg13_lv_pmos ad=95f pd=0.88u as=0 ps=0 w=0.5u l=0.5u
X54 vdd_1v2.t333 vdd_1v2.t360 ota_cmfb_top_0.ota_cmfb_core_push_pull_output_stage_0/dynamic_pcell$4_0.SRC_NET_IJ_GATE_DI vdd_1v2.t0 sg13_lv_pmos ad=0.475p pd=2.88u as=0.475p ps=2.88u w=2.5u l=0.5u
X55 vdd_1v2.t22 ota_cmfb_top_0.dynamic_pcell$5_0.G_DRN ota_cmfb_top_0.ota_cmfb_core_push_pull_output_stage_1/dynamic_pcell$4_0.B_DRN vdd_1v2.t0 sg13_lv_pmos ad=0.475p pd=2.88u as=0.475p ps=2.88u w=2.5u l=3u
X56 ota_cmfb_top_0.dynamic_pcell$5_0.DRN_NET_CA analog_bus0 ota_cmfb_top_0.dynamic_pcell$5_0.SRC_NET_AB vdd_1v2.t0 sg13_lv_pmos ad=0.475p pd=2.88u as=0.475p ps=2.88u w=2.5u l=2u
X57 ota_cmfb_top_0.dynamic_pcell$5_0.G_DRN.t1 vss_1v2.t102 vss_1v2.t91 vss_1v2.t70 sg13_lv_nmos ad=62.5f pd=0.74u as=62.5f ps=0.74u w=0.25u l=0.5u
X58 ota_cmfb_top_0.dynamic_pcell$5_0.DRN_NET_CA ota_cmfb_top_0.ota_cmfb_core_push_pull_output_stage_1/dynamic_pcell$4_0.DRN_NET_J_GATE_EJ ota_cmfb_top_0.ota_cmfb_core_push_pull_output_stage_1/dynamic_pcell$4_0.DRN_NET_MENX vdd_1v2.t0 sg13_lv_pmos ad=0.85p pd=5.68u as=0.475p ps=2.88u w=2.5u l=3u
X59 vdd_1v2.t37 vdd_1v2.t148 vdd_1v2.t149 vdd_1v2.t0 sg13_lv_pmos ad=0.475p pd=2.88u as=0 ps=0 w=2.5u l=0.5u
X60 vdd_1v2.t8 ota_cmfb_top_0.dynamic_pcell$5_0.G_DRN ota_cmfb_top_0.dynamic_pcell$5_0.G_DRN.t3 vdd_1v2.t0 sg13_lv_pmos ad=0.475p pd=2.88u as=0.85p ps=5.68u w=2.5u l=3u
X61 ota_cmfb_top_0.ota_cmfb_core_push_pull_output_stage_1/dynamic_pcell$4_0.DRN_NET_MENX ota_cmfb_top_0.ota_cmfb_core_push_pull_output_stage_1/dynamic_pcell$4_0.B_DRN ota_cmfb_top_0.dynamic_pcell$5_0.DRN_NET_CA vss_1v2.t21 sg13_lv_nmos ad=0.133p pd=1.08u as=0.133p ps=1.08u w=0.7u l=3u
X62 vss_1v2.t56 enable.t0 ota_cmfb_top_0.ota_cmfb_core_push_pull_output_stage_0/EN_INV_0/sg13cmos5l_inv_4_0.Y vss_1v2.t62 sg13_lv_nmos ad=0.1406p pd=1.12u as=0.1406p ps=1.12u w=0.74u l=0.13u
X63 vdd_1v2.t398 vdd_1v2.t396 vdd_1v2.t392 vdd_1v2.t0 sg13_lv_pmos ad=0.475p pd=2.88u as=0 ps=0 w=2.5u l=0.5u
X64 vdd_1v2.t9 ota_cmfb_top_0.dynamic_pcell$5_0.G_DRN ota_cmfb_top_0.dynamic_pcell$5_0.G_DRN.t0 vdd_1v2.t0 sg13_lv_pmos ad=0.475p pd=2.88u as=0.475p ps=2.88u w=2.5u l=3u
X65 enable.t5 vdd_1v2.t0 dpantenna l=1.34u w=1.05u
X66 vdd_1v2.t155 vdd_1v2.t153 vdd_1v2.t154 vdd_1v2.t0 sg13_lv_pmos ad=0.17p pd=1.68u as=0 ps=0 w=0.5u l=0.5u
X67 a_50132_27418# a_49868_27132# vss_1v2.t40 rhigh l=1u w=0.5u
X68 ota_cmfb_top_0.ota_cmfb_core_push_pull_output_stage_0/dynamic_pcell$4_0.Gate ota_cmfb_top_0.ota_cmfb_core_push_pull_output_stage_0/dynamic_pcell$4_0.Gate vss_1v2.t349 vss_1v2.t0 sg13_lv_nmos ad=0.133p pd=1.08u as=0.133p ps=1.08u w=0.7u l=3u
X69 vdd_1v2.t17 ota_cmfb_top_0.dynamic_pcell$5_0.G_DRN ota_cmfb_top_0.dynamic_pcell$5_0.G_DRN.t11 vdd_1v2.t0 sg13_lv_pmos ad=0.85p pd=5.68u as=0.475p ps=2.88u w=2.5u l=3u
X70 vdd_1v2.t468 ota_cmfb_top_0.dynamic_pcell$5_0.DRN_NET_BD s5_an[2] vdd_1v2.t0 sg13_lv_pmos ad=95f pd=0.88u as=95f ps=0.88u w=0.5u l=0.5u
X71 vss_1v2.t74 vss_1v2.t72 vss_1v2.t74 vss_1v2.t73 sg13_lv_nmos ad=62.5f pd=0.74u as=0 ps=0 w=0.25u l=0.5u
X72 ota_cmfb_top_0.ota_cmfb_core_push_pull_output_stage_1/dynamic_pcell$4_0.DRN_NET_HI ota_cmfb_top_0.dynamic_pcell$5_0.G_DRN vdd_1v2.t3 vdd_1v2.t0 sg13_lv_pmos ad=0.475p pd=2.88u as=0.475p ps=2.88u w=2.5u l=3u
X73 vdd_1v2.t51 vdd_1v2.t49 vdd_1v2.t48 vdd_1v2.t0 sg13_lv_pmos ad=0.2375p pd=1.63u as=0 ps=0 w=1.25u l=0.5u
X74 vdd_1v2.t134 vdd_1v2.t133 ota_cmfb_top_0.dynamic_pcell$5_0.DRN_NET_JL.t0 vdd_1v2.t0 sg13_lv_pmos ad=0.475p pd=2.88u as=0.475p ps=2.88u w=2.5u l=0.5u
X75 vdd_1v2.t152 vdd_1v2.t150 vdd_1v2.t151 vdd_1v2.t0 sg13_lv_pmos ad=0.85p pd=5.68u as=0 ps=0 w=2.5u l=0.5u
X76 ota_cmfb_top_0.ota_cmfb_core_push_pull_output_stage_1/dynamic_pcell$4_0.Gate ota_cmfb_top_0.ota_cmfb_core_push_pull_output_stage_1/dynamic_pcell$4_0.Gate vss_1v2.t20 vss_1v2.t24 sg13_lv_nmos ad=0.133p pd=1.08u as=0.133p ps=1.08u w=0.7u l=3u
X77 vss_1v2.t34 ota_cmfb_top_0.dynamic_pcell$5_0.DRN_NET_E_GATE_CDEFGH ota_cmfb_top_0.dynamic_pcell$5_0.DRN_NET_BD vss_1v2.t317 sg13_lv_nmos ad=62.5f pd=0.74u as=62.5f ps=0.74u w=0.25u l=10u
X78 ota_cmfb_top_0.ota_cmfb_core_push_pull_output_stage_1/dynamic_pcell$4_0.SRC_NET_ML ota_cmfb_top_0.ota_cmfb_core_push_pull_output_stage_1/dynamic_pcell$4_0.Gate vss_1v2.t20 vss_1v2.t29 sg13_lv_nmos ad=0.133p pd=1.08u as=0.133p ps=1.08u w=0.7u l=3u
X79 ota_cmfb_top_0.ota_cmfb_core_push_pull_output_stage_0/dynamic_pcell$4_0.Gate ota_cmfb_top_0.ota_cmfb_core_push_pull_output_stage_0/dynamic_pcell$4_0.Gate vss_1v2.t349 vss_1v2.t2 sg13_lv_nmos ad=0.133p pd=1.08u as=0.133p ps=1.08u w=0.7u l=3u
X80 ota_cmfb_top_0.ota_cmfb_core_push_pull_output_stage_0/dynamic_pcell$4_0.DRN_NET_MENX vss_1v2.t195 vss_1v2.t197 vss_1v2.t196 sg13_lv_nmos ad=0.133p pd=1.08u as=0.133p ps=1.08u w=0.7u l=0.5u
X81 vdd_1v2.t378 vdd_1v2.t376 vdd_1v2.t377 vdd_1v2.t0 sg13_lv_pmos ad=0.475p pd=2.88u as=0 ps=0 w=2.5u l=0.5u
X82 vdd_1v2.t139 vdd_1v2.t137 vdd_1v2.t138 vdd_1v2.t0 sg13_lv_pmos ad=0.85p pd=5.68u as=0 ps=0 w=2.5u l=0.5u
X83 vss_1v2.t211 vss_1v2.t209 ota_cmfb_top_0.ota_cmfb_core_push_pull_output_stage_0/dynamic_pcell$4_0.DRN_NET_OP_GATE_MP vss_1v2.t210 sg13_lv_nmos ad=0.133p pd=1.08u as=0.133p ps=1.08u w=0.7u l=0.5u
X84 vdd_1v2.t25 ota_cmfb_top_0.dynamic_pcell$5_0.DRN_NET_CA s5_an[1] vdd_1v2.t0 sg13_lv_pmos ad=95f pd=0.88u as=95f ps=0.88u w=0.5u l=0.5u
X85 vss_1v2.t263 vss_1v2.t261 vss_1v2.t260 vss_1v2.t206 sg13_lv_nmos ad=0.133p pd=1.08u as=0 ps=0 w=0.7u l=0.5u
X86 vss_1v2.t286 vss_1v2.t284 vss_1v2.t286 vss_1v2.t287 sg13_lv_nmos ad=95f pd=0.88u as=0 ps=0 w=0.5u l=0.5u
X87 ota_cmfb_top_0.dynamic_pcell$5_0.DRN_NET_E_GATE_CDEFGH.t1 vss_1v2.t75 vss_1v2.t76 vss_1v2.t70 sg13_lv_nmos ad=62.5f pd=0.74u as=62.5f ps=0.74u w=0.25u l=0.5u
X88 vdd_1v2.t270 vdd_1v2.t258 vdd_1v2.t272 vdd_1v2.t0 sg13_lv_pmos ad=95f pd=0.88u as=0 ps=0 w=0.5u l=0.5u
X89 vss_1v2.t20 ota_cmfb_top_0.ota_cmfb_core_push_pull_output_stage_1/dynamic_pcell$4_0.Gate ota_cmfb_top_0.ota_cmfb_core_push_pull_output_stage_1/dynamic_pcell$4_0.Gate vss_1v2.t21 sg13_lv_nmos ad=0.133p pd=1.08u as=0.133p ps=1.08u w=0.7u l=3u
X90 vss_1v2.t246 vss_1v2.t246 vss_1v2.t246 vss_1v2.t264 sg13_lv_nmos ad=0.17p pd=1.68u as=0 ps=0 w=0.5u l=0.5u
X91 vss_1v2.t12 vss_1v2.t12 vss_1v2.t12 vss_1v2.t278 sg13_lv_nmos ad=95f pd=0.88u as=0 ps=0 w=0.5u l=0.5u
X92 vss_1v2.t134 vss_1v2.t133 vss_1v2.t134 vss_1v2.t73 sg13_lv_nmos ad=62.5f pd=0.74u as=0 ps=0 w=0.25u l=0.5u
X93 ota_cmfb_top_0.ota_cmfb_core_push_pull_output_stage_1/dynamic_pcell$4_0.DRN_NET_J_GATE_EJ ota_cmfb_top_0.ota_cmfb_core_push_pull_output_stage_1/dynamic_pcell$4_0.DRN_NET_J_GATE_EJ ota_cmfb_top_0.ota_cmfb_core_push_pull_output_stage_1/dynamic_pcell$4_0.SRC_NET_IJ_GATE_DI vdd_1v2.t0 sg13_lv_pmos ad=0.475p pd=2.88u as=0.475p ps=2.88u w=2.5u l=3u
X94 ota_cmfb_top_0.ota_cmfb_core_push_pull_output_stage_1/EN_INV_0/sg13cmos5l_inv_4_0.Y enable.t1 vss_1v2.t58 vss_1v2.t60 sg13_lv_nmos ad=0.1406p pd=1.12u as=0.1406p ps=1.12u w=0.74u l=0.13u
X95 vdd_1v2.t170 vdd_1v2.t153 vdd_1v2.t172 vdd_1v2.t0 sg13_lv_pmos ad=95f pd=0.88u as=0 ps=0 w=0.5u l=0.5u
X96 ota_cmfb_top_0.ota_cmfb_core_push_pull_output_stage_0/EN_INV_0/sg13cmos5l_inv_4_0.Y enable.t0 vss_1v2.t56 vss_1v2.t63 sg13_lv_nmos ad=0.1406p pd=1.12u as=0.1406p ps=1.12u w=0.74u l=0.13u
X97 vss_1v2.t87 vss_1v2.t86 vss_1v2.t87 vss_1v2.t73 sg13_lv_nmos ad=62.5f pd=0.74u as=0 ps=0 w=0.25u l=0.5u
X98 vss_1v2.t20 ota_cmfb_top_0.ota_cmfb_core_push_pull_output_stage_1/dynamic_pcell$4_0.Gate ota_cmfb_top_0.ota_cmfb_core_push_pull_output_stage_1/dynamic_pcell$4_0.Gate vss_1v2.t19 sg13_lv_nmos ad=0.133p pd=1.08u as=0.133p ps=1.08u w=0.7u l=3u
X99 vdd_1v2.t419 enable.t0 ota_cmfb_top_0.ota_cmfb_core_push_pull_output_stage_0/EN_INV_0/sg13cmos5l_inv_4_0.Y vdd_1v2.t0 sg13_lv_pmos ad=0.2128p pd=1.5u as=0.2128p ps=1.5u w=1.12u l=0.13u
X100 vdd_1v2.t179 vdd_1v2.t177 vdd_1v2.t178 vdd_1v2.t0 sg13_lv_pmos ad=0.17p pd=1.68u as=0 ps=0 w=0.5u l=0.5u
X101 ota_cmfb_top_0.dynamic_pcell$5_0.DRN_NET_CA ota_cmfb_top_0.ota_cmfb_core_push_pull_output_stage_1/dynamic_pcell$4_0.B_DRN ota_cmfb_top_0.ota_cmfb_core_push_pull_output_stage_1/dynamic_pcell$4_0.DRN_NET_MENX vss_1v2.t24 sg13_lv_nmos ad=0.133p pd=1.08u as=0.133p ps=1.08u w=0.7u l=3u
X102 vdd_1v2.t182 vdd_1v2.t177 vdd_1v2.t184 vdd_1v2.t0 sg13_lv_pmos ad=95f pd=0.88u as=0 ps=0 w=0.5u l=0.5u
X103 vss_1v2.t34 ota_cmfb_top_0.dynamic_pcell$5_0.DRN_NET_E_GATE_CDEFGH ota_cmfb_top_0.dynamic_pcell$5_0.DRN_NET_BD vss_1v2.t317 sg13_lv_nmos ad=62.5f pd=0.74u as=62.5f ps=0.74u w=0.25u l=10u
X104 ota_cmfb_top_0.dynamic_pcell$5_0.DRN_NET_BD ota_cmfb_top_0.ota_cmfb_core_push_pull_output_stage_0/dynamic_pcell$4_0.B_DRN ota_cmfb_top_0.ota_cmfb_core_push_pull_output_stage_0/dynamic_pcell$4_0.DRN_NET_MENX vss_1v2.t2 sg13_lv_nmos ad=0.133p pd=1.08u as=0.133p ps=1.08u w=0.7u l=3u
X105 ota_cmfb_top_0.ota_cmfb_core_push_pull_output_stage_0/dynamic_pcell$4_0.DRN_NET_OP_GATE_MP vss_1v2.t250 vss_1v2.t242 vss_1v2.t196 sg13_lv_nmos ad=0.133p pd=1.08u as=0.133p ps=1.08u w=0.7u l=0.5u
X106 vss_1v2.t311 a_45783_27500# dantenna l=0.78u w=0.78u
X107 vdd_1v2.t260 vdd_1v2.t258 vdd_1v2.t259 vdd_1v2.t0 sg13_lv_pmos ad=0.17p pd=1.68u as=0 ps=0 w=0.5u l=0.5u
X108 ota_cmfb_top_0.dynamic_pcell$5_0.SRC_NET_KL.t4 ota_cmfb_top_0.dynamic_pcell$5_0.H_DRN vdd_1v2.t60 vdd_1v2.t0 sg13_lv_pmos ad=0.2375p pd=1.63u as=0.2375p ps=1.63u w=1.25u l=5u
X109 vss_1v2.t18 vss_1v2.t297 vss_1v2.t18 vss_1v2.t303 sg13_lv_nmos ad=95f pd=0.88u as=0 ps=0 w=0.5u l=0.5u
X110 vss_1v2.t349 ota_cmfb_top_0.ota_cmfb_core_push_pull_output_stage_0/dynamic_pcell$4_0.Gate ota_cmfb_top_0.ota_cmfb_core_push_pull_output_stage_0/dynamic_pcell$4_0.SRC_NET_ML vss_1v2.t4 sg13_lv_nmos ad=0.133p pd=1.08u as=0.133p ps=1.08u w=0.7u l=3u
X111 vss_1v2.t236 vss_1v2.t235 ota_cmfb_top_0.ota_cmfb_core_push_pull_output_stage_0/dynamic_pcell$4_0.DRN_NET_MENX vss_1v2.t210 sg13_lv_nmos ad=0.133p pd=1.08u as=0.133p ps=1.08u w=0.7u l=0.5u
X112 vdd_1v2.t68 vdd_1v2.t67 ota_cmfb_top_0.dynamic_pcell$5_0.H_DRN.t0 vdd_1v2.t0 sg13_lv_pmos ad=0.2375p pd=1.63u as=0.2375p ps=1.63u w=1.25u l=0.5u
X113 vdd_1v2.t104 ota_cmfb_top_0.dynamic_pcell$5_0.H_DRN ota_cmfb_top_0.dynamic_pcell$5_0.SRC_NET_KL.t7 vdd_1v2.t0 sg13_lv_pmos ad=0.2375p pd=1.63u as=0.2375p ps=1.63u w=1.25u l=5u
X114 ota_cmfb_top_0.ota_cmfb_core_push_pull_output_stage_1/dynamic_pcell$4_0.DRN_NET_CD ota_cmfb_top_0.dynamic_pcell$5_0.G_DRN vdd_1v2.t5 vdd_1v2.t0 sg13_lv_pmos ad=0.475p pd=2.88u as=0.475p ps=2.88u w=2.5u l=3u
X115 ota_cmfb_top_0.dynamic_pcell$5_0.H_DRN.t3 vss_1v2.t113 vss_1v2.t94 vss_1v2.t70 sg13_lv_nmos ad=62.5f pd=0.74u as=62.5f ps=0.74u w=0.25u l=0.5u
X116 vdd_1v2.t90 vdd_1v2.t92 vdd_1v2.t93 vdd_1v2.t0 sg13_lv_pmos ad=0.2375p pd=1.63u as=0 ps=0 w=1.25u l=0.5u
X117 vdd_1v2.t29 ota_cmfb_top_0.dynamic_pcell$5_0.DRN_NET_CA s5_an[1] vdd_1v2.t0 sg13_lv_pmos ad=95f pd=0.88u as=95f ps=0.88u w=0.5u l=0.5u
X118 ota_cmfb_top_0.ota_cmfb_core_push_pull_output_stage_1/dynamic_pcell$4_0.SRC_NET_ML vss_1v2.t152 vss_1v2.t150 vss_1v2.t153 sg13_lv_nmos ad=0.133p pd=1.08u as=0.133p ps=1.08u w=0.7u l=0.5u
X119 vdd_1v2.t31 ota_cmfb_top_0.dynamic_pcell$5_0.DRN_NET_CA s5_an[1] vdd_1v2.t0 sg13_lv_pmos ad=95f pd=0.88u as=95f ps=0.88u w=0.5u l=0.5u
X120 a_58402_34440# a_58666_34154# vss_1v2.t13 rhigh l=1u w=0.5u
X121 vdd_1v2.t466 ota_cmfb_top_0.dynamic_pcell$5_0.DRN_NET_BD s5_an[2] vdd_1v2.t0 sg13_lv_pmos ad=95f pd=0.88u as=95f ps=0.88u w=0.5u l=0.5u
X122 vdd_1v2.t331 vdd_1v2.t329 vdd_1v2.t330 vdd_1v2.t0 sg13_lv_pmos ad=0.475p pd=2.88u as=0 ps=0 w=2.5u l=0.5u
X123 vdd_1v2.t0 vdd_1v2.t38 vdd_1v2.t0 vdd_1v2.t0 sg13_lv_pmos ad=0.425p pd=3.18u as=0 ps=0 w=1.25u l=0.5u
X124 ota_cmfb_top_0.ota_cmfb_core_push_pull_output_stage_1/dynamic_pcell$4_0.DRN_NET_MENX vss_1v2.t166 vss_1v2.t167 vss_1v2.t19 sg13_lv_nmos ad=0.133p pd=1.08u as=0.133p ps=1.08u w=0.7u l=3u
X125 ota_cmfb_top_0.ota_cmfb_core_push_pull_output_stage_1/dynamic_pcell$4_0.Gate ota_cmfb_top_0.ota_cmfb_core_push_pull_output_stage_1/dynamic_pcell$4_0.DRN_NET_OP_GATE_MP ota_cmfb_top_0.ota_cmfb_core_push_pull_output_stage_1/dynamic_pcell$4_0.DRN_NET_OP_GATE_MP vss_1v2.t24 sg13_lv_nmos ad=0.133p pd=1.08u as=0.133p ps=1.08u w=0.7u l=3u
X126 vss_1v2.t58 enable.t1 ota_cmfb_top_0.ota_cmfb_core_push_pull_output_stage_1/EN_INV_0/sg13cmos5l_inv_4_0.Y vss_1v2.t61 sg13_lv_nmos ad=0.2516p pd=2.16u as=0.1406p ps=1.12u w=0.74u l=0.13u
X127 ota_cmfb_top_0.dynamic_pcell$5_0.DRN_NET_CA analog_bus0 ota_cmfb_top_0.dynamic_pcell$5_0.SRC_NET_AB vdd_1v2.t0 sg13_lv_pmos ad=0.475p pd=2.88u as=0.85p ps=5.68u w=2.5u l=2u
X128 vss_1v2.t34 ota_cmfb_top_0.dynamic_pcell$5_0.DRN_NET_E_GATE_CDEFGH ota_cmfb_top_0.dynamic_pcell$5_0.DRN_NET_CA vss_1v2.t317 sg13_lv_nmos ad=62.5f pd=0.74u as=62.5f ps=0.74u w=0.25u l=10u
X129 ota_cmfb_top_0.ota_cmfb_core_push_pull_output_stage_0/dynamic_pcell$4_0.Gate ota_cmfb_top_0.ota_cmfb_core_push_pull_output_stage_0/dynamic_pcell$4_0.DRN_NET_OP_GATE_MP ota_cmfb_top_0.ota_cmfb_core_push_pull_output_stage_0/dynamic_pcell$4_0.DRN_NET_OP_GATE_MP vss_1v2.t2 sg13_lv_nmos ad=0.133p pd=1.08u as=0.133p ps=1.08u w=0.7u l=3u
X130 vdd_1v2.t123 vdd_1v2.t121 vdd_1v2.t120 vdd_1v2.t0 sg13_lv_pmos ad=0.2375p pd=1.63u as=0 ps=0 w=1.25u l=0.5u
X131 ota_cmfb_top_0.ota_cmfb_core_push_pull_output_stage_1/EN_INV_0/sg13cmos5l_inv_4_0.Y enable.t1 vdd_1v2.t415 vdd_1v2.t0 sg13_lv_pmos ad=0.2128p pd=1.5u as=0.2128p ps=1.5u w=1.12u l=0.13u
X132 vdd_1v2.t13 ota_cmfb_top_0.dynamic_pcell$5_0.G_DRN ota_cmfb_top_0.dynamic_pcell$5_0.G_DRN.t6 vdd_1v2.t0 sg13_lv_pmos ad=0.475p pd=2.88u as=0.475p ps=2.88u w=2.5u l=3u
X133 ota_cmfb_top_0.dynamic_pcell$5_0.DRN_NET_CA ota_cmfb_top_0.ota_cmfb_core_push_pull_output_stage_1/dynamic_pcell$4_0.DRN_NET_J_GATE_EJ ota_cmfb_top_0.ota_cmfb_core_push_pull_output_stage_1/dynamic_pcell$4_0.DRN_NET_MENX vdd_1v2.t0 sg13_lv_pmos ad=0.475p pd=2.88u as=0.85p ps=5.68u w=2.5u l=3u
X134 vdd_1v2.t193 vdd_1v2.t177 vdd_1v2.t190 vdd_1v2.t0 sg13_lv_pmos ad=95f pd=0.88u as=0 ps=0 w=0.5u l=0.5u
X135 ota_cmfb_top_0.ota_cmfb_core_push_pull_output_stage_0/EN_INV_0/sg13cmos5l_inv_4_0.Y enable.t0 vdd_1v2.t419 vdd_1v2.t0 sg13_lv_pmos ad=0.2128p pd=1.5u as=0.2128p ps=1.5u w=1.12u l=0.13u
X136 ota_cmfb_top_0.dynamic_pcell$5_0.SRC_NET_KL.t5 ota_cmfb_top_0.dynamic_pcell$5_0.H_DRN vdd_1v2.t60 vdd_1v2.t0 sg13_lv_pmos ad=0.2375p pd=1.63u as=0.2375p ps=1.63u w=1.25u l=5u
X137 a_50396_27979# a_50132_27693# vss_1v2.t10 rhigh l=1u w=0.5u
X138 vss_1v2.t253 vss_1v2.t252 ota_cmfb_top_0.ota_cmfb_core_push_pull_output_stage_0/dynamic_pcell$4_0.DRN_NET_OP_GATE_MP vss_1v2.t210 sg13_lv_nmos ad=0.133p pd=1.08u as=0.133p ps=1.08u w=0.7u l=0.5u
X139 ota_cmfb_top_0.ota_cmfb_core_push_pull_output_stage_1/dynamic_pcell$4_0.Gate ota_cmfb_top_0.ota_cmfb_core_push_pull_output_stage_1/dynamic_pcell$4_0.DRN_NET_OP_GATE_MP ota_cmfb_top_0.ota_cmfb_core_push_pull_output_stage_1/dynamic_pcell$4_0.DRN_NET_OP_GATE_MP vss_1v2.t22 sg13_lv_nmos ad=0.133p pd=1.08u as=0.133p ps=1.08u w=0.7u l=3u
X140 ota_cmfb_top_0.dynamic_pcell$5_0.SRC_NET_AB analog_bus0 ota_cmfb_top_0.dynamic_pcell$5_0.DRN_NET_CA vdd_1v2.t0 sg13_lv_pmos ad=0.475p pd=2.88u as=0.475p ps=2.88u w=2.5u l=2u
X141 vdd_1v2.t366 vdd_1v2.t364 vdd_1v2.t339 vdd_1v2.t0 sg13_lv_pmos ad=0.475p pd=2.88u as=0 ps=0 w=2.5u l=0.5u
X142 vdd_1v2.t71 vdd_1v2.t69 vdd_1v2.t68 vdd_1v2.t0 sg13_lv_pmos ad=0.2375p pd=1.63u as=0 ps=0 w=1.25u l=0.5u
X143 ota_cmfb_top_0.dynamic_pcell$5_0.F_DRN.t2 vss_1v2.t122 vss_1v2.t120 vss_1v2.t70 sg13_lv_nmos ad=62.5f pd=0.74u as=62.5f ps=0.74u w=0.25u l=0.5u
X144 a_58666_33917# a_58930_33631# vss_1v2.t14 rhigh l=1u w=0.5u
X145 vdd_1v2.t65 vdd_1v2.t64 vdd_1v2.t249 vdd_1v2.t0 sg13_lv_pmos ad=95f pd=0.88u as=0 ps=0 w=0.5u l=0.5u
X146 ota_cmfb_top_0.ota_cmfb_core_push_pull_output_stage_1/dynamic_pcell$4_0.Gate ota_cmfb_top_0.ota_cmfb_core_push_pull_output_stage_1/EN_INV_0/sg13cmos5l_inv_4_0.Y vss_1v2.t332 vss_1v2.t331 sg13_lv_nmos ad=0.2516p pd=2.16u as=0.2516p ps=2.16u w=0.74u l=0.13u
X147 vdd_1v2.t372 vdd_1v2.t370 vdd_1v2.t371 vdd_1v2.t0 sg13_lv_pmos ad=0.475p pd=2.88u as=0 ps=0 w=2.5u l=0.5u
X148 ota_cmfb_top_0.EN_INV_1/sg13cmos5l_inv_4_0.Y enable.t3 vss_1v2.t47 vss_1v2.t45 sg13_lv_nmos ad=0.1406p pd=1.12u as=0.1406p ps=1.12u w=0.74u l=0.13u
X149 ota_cmfb_top_0.ota_cmfb_core_push_pull_output_stage_1/dynamic_pcell$4_0.SRC_NET_IJ_GATE_DI ota_cmfb_top_0.ota_cmfb_core_push_pull_output_stage_1/dynamic_pcell$4_0.DRN_NET_J_GATE_EJ ota_cmfb_top_0.ota_cmfb_core_push_pull_output_stage_1/dynamic_pcell$4_0.DRN_NET_J_GATE_EJ vdd_1v2.t0 sg13_lv_pmos ad=0.475p pd=2.88u as=0.475p ps=2.88u w=2.5u l=3u
X150 ota_cmfb_top_0.dynamic_pcell$5_0.H_DRN.t1 vdd_1v2.t111 vdd_1v2.t62 vdd_1v2.t0 sg13_lv_pmos ad=0.2375p pd=1.63u as=0.2375p ps=1.63u w=1.25u l=0.5u
X151 a_51669_33917# a_51669_33631# vss_1v2.t8 rhigh l=1u w=0.5u
X152 vdd_1v2.t166 vdd_1v2.t153 vdd_1v2.t168 vdd_1v2.t0 sg13_lv_pmos ad=95f pd=0.88u as=0 ps=0 w=0.5u l=0.5u
X153 vss_1v2.t46 enable.t4 ota_cmfb_top_0.EN_INV_0/sg13cmos5l_inv_4_0.Y vss_1v2.t45 sg13_lv_nmos ad=0.2516p pd=2.16u as=0.1406p ps=1.12u w=0.74u l=0.13u
X154 vdd_1v2.t334 vdd_1v2.t332 vdd_1v2.t333 vdd_1v2.t0 sg13_lv_pmos ad=0.475p pd=2.88u as=0 ps=0 w=2.5u l=0.5u
X155 ota_cmfb_top_0.ota_cmfb_core_push_pull_output_stage_1/dynamic_pcell$4_0.DRN_NET_OP_GATE_MP ota_cmfb_top_0.ota_cmfb_core_push_pull_output_stage_1/dynamic_pcell$4_0.B_DRN ota_cmfb_top_0.ota_cmfb_core_push_pull_output_stage_1/dynamic_pcell$4_0.B_DRN vss_1v2.t19 sg13_lv_nmos ad=0.133p pd=1.08u as=0.133p ps=1.08u w=0.7u l=3u
X156 vss_1v2.t18 vss_1v2.t297 vss_1v2.t18 vss_1v2.t299 sg13_lv_nmos ad=95f pd=0.88u as=0 ps=0 w=0.5u l=0.5u
X157 ota_cmfb_top_0.dynamic_pcell$5_0.SRC_NET_AB analog_bus0 ota_cmfb_top_0.dynamic_pcell$5_0.DRN_NET_CA vdd_1v2.t0 sg13_lv_pmos ad=0.475p pd=2.88u as=0.475p ps=2.88u w=2.5u l=2u
X158 a_50132_27418# a_50396_27132# vss_1v2.t309 rhigh l=1u w=0.5u
X159 vss_1v2.t167 vss_1v2.t166 ota_cmfb_top_0.ota_cmfb_core_push_pull_output_stage_1/dynamic_pcell$4_0.DRN_NET_MENX vss_1v2.t22 sg13_lv_nmos ad=0.133p pd=1.08u as=0.133p ps=1.08u w=0.7u l=3u
X160 ota_cmfb_top_0.dynamic_pcell$5_0.DRN_NET_JL.t3 ota_cmfb_top_0.dynamic_pcell$5_0.Gate vss_1v2.t316 vss_1v2.t317 sg13_lv_nmos ad=62.5f pd=0.74u as=62.5f ps=0.74u w=0.25u l=10u
X161 vdd_1v2.t27 ota_cmfb_top_0.dynamic_pcell$5_0.DRN_NET_CA s5_an[1] vdd_1v2.t0 sg13_lv_pmos ad=95f pd=0.88u as=95f ps=0.88u w=0.5u l=0.5u
X162 vdd_1v2.t18 ota_cmfb_top_0.dynamic_pcell$5_0.G_DRN ota_cmfb_top_0.ota_cmfb_core_push_pull_output_stage_1/dynamic_pcell$4_0.DRN_NET_HI vdd_1v2.t0 sg13_lv_pmos ad=0.475p pd=2.88u as=0.475p ps=2.88u w=2.5u l=3u
X163 vdd_1v2.t417 enable.t1 ota_cmfb_top_0.ota_cmfb_core_push_pull_output_stage_1/EN_INV_0/sg13cmos5l_inv_4_0.Y vdd_1v2.t0 sg13_lv_pmos ad=0.3808p pd=2.92u as=0.2128p ps=1.5u w=1.12u l=0.13u
X164 ota_cmfb_top_0.dynamic_pcell$5_0.SRC_NET_KL.t3 vdd_1v2.t159 vdd_1v2.t151 vdd_1v2.t0 sg13_lv_pmos ad=0.475p pd=2.88u as=0.475p ps=2.88u w=2.5u l=0.5u
X165 ota_cmfb_top_0.ota_cmfb_core_push_pull_output_stage_1/dynamic_pcell$4_0.DRN_NET_OP_GATE_MP ota_cmfb_top_0.ota_cmfb_core_push_pull_output_stage_1/dynamic_pcell$4_0.B_DRN ota_cmfb_top_0.ota_cmfb_core_push_pull_output_stage_1/dynamic_pcell$4_0.B_DRN vss_1v2.t29 sg13_lv_nmos ad=0.133p pd=1.08u as=0.133p ps=1.08u w=0.7u l=3u
X166 s5_an[2] a_58930_33631# vss_1v2.t15 rhigh l=1u w=0.5u
X167 vdd_1v2.t387 vdd_1v2.t385 vdd_1v2.t377 vdd_1v2.t0 sg13_lv_pmos ad=0.475p pd=2.88u as=0 ps=0 w=2.5u l=0.5u
X168 ota_cmfb_top_0.dynamic_pcell$5_0.SRC_NET_AB vdd_1v2.t140 vdd_1v2.t138 vdd_1v2.t0 sg13_lv_pmos ad=0.475p pd=2.88u as=0.475p ps=2.88u w=2.5u l=0.5u
X169 vss_1v2.t67 vss_1v2.t69 vss_1v2.t71 vss_1v2.t70 sg13_lv_nmos ad=62.5f pd=0.74u as=0 ps=0 w=0.25u l=0.5u
X170 vss_1v2.t223 vss_1v2.t221 vss_1v2.t211 vss_1v2.t206 sg13_lv_nmos ad=0.133p pd=1.08u as=0 ps=0 w=0.7u l=0.5u
X171 vdd_1v2.t158 vdd_1v2.t153 vdd_1v2.t157 vdd_1v2.t0 sg13_lv_pmos ad=95f pd=0.88u as=0 ps=0 w=0.5u l=0.5u
X172 vss_1v2.t47 enable.t3 ota_cmfb_top_0.EN_INV_1/sg13cmos5l_inv_4_0.Y vss_1v2.t45 sg13_lv_nmos ad=0.2516p pd=2.16u as=0.1406p ps=1.12u w=0.74u l=0.13u
X173 vss_1v2.t286 vss_1v2.t284 vss_1v2.t286 vss_1v2.t295 sg13_lv_nmos ad=95f pd=0.88u as=0 ps=0 w=0.5u l=0.5u
X174 vdd_1v2.t117 vdd_1v2.t115 vdd_1v2.t107 vdd_1v2.t0 sg13_lv_pmos ad=0.2375p pd=1.63u as=0 ps=0 w=1.25u l=0.5u
X175 ota_cmfb_top_0.ota_cmfb_core_push_pull_output_stage_0/dynamic_pcell$4_0.DRN_NET_MENX ota_cmfb_top_0.ota_cmfb_core_push_pull_output_stage_0/dynamic_pcell$4_0.DRN_NET_OP_GATE_MP ota_cmfb_top_0.ota_cmfb_core_push_pull_output_stage_0/dynamic_pcell$4_0.SRC_NET_ML vss_1v2.t4 sg13_lv_nmos ad=0.133p pd=1.08u as=0.133p ps=1.08u w=0.7u l=3u
X176 vdd_1v2.t186 vdd_1v2.t177 vdd_1v2.t188 vdd_1v2.t0 sg13_lv_pmos ad=95f pd=0.88u as=0 ps=0 w=0.5u l=0.5u
X177 vdd_1v2.t239 vdd_1v2.t237 vdd_1v2.t238 vdd_1v2.t0 sg13_lv_pmos ad=0.475p pd=2.88u as=0 ps=0 w=2.5u l=0.5u
X178 vdd_1v2.t110 vdd_1v2.t108 vdd_1v2.t35 vdd_1v2.t0 sg13_lv_pmos ad=0.85p pd=5.68u as=0 ps=0 w=2.5u l=0.5u
X179 ota_cmfb_top_0.dynamic_pcell$5_0.Gate s5_an[0] ota_cmfb_top_0.dynamic_pcell$5_0.SRC_NET_KL.t1 vdd_1v2.t0 sg13_lv_pmos ad=0.85p pd=5.68u as=0.475p ps=2.88u w=2.5u l=2u
X180 vss_1v2.t246 vss_1v2.t246 vss_1v2.t246 vss_1v2.t270 sg13_lv_nmos ad=95f pd=0.88u as=0 ps=0 w=0.5u l=0.5u
X181 ota_cmfb_top_0.dynamic_pcell$5_0.DRN_NET_CA ota_cmfb_top_0.dynamic_pcell$5_0.DRN_NET_E_GATE_CDEFGH vss_1v2.t320 vss_1v2.t317 sg13_lv_nmos ad=62.5f pd=0.74u as=62.5f ps=0.74u w=0.25u l=10u
X182 vdd_1v2.t390 vdd_1v2.t388 vdd_1v2.t389 vdd_1v2.t0 sg13_lv_pmos ad=0.85p pd=5.68u as=0 ps=0 w=2.5u l=0.5u
X183 ota_cmfb_top_0.ota_cmfb_core_push_pull_output_stage_1/dynamic_pcell$4_0.SRC_NET_ML vss_1v2.t193 vss_1v2.t191 vss_1v2.t153 sg13_lv_nmos ad=0.133p pd=1.08u as=0.133p ps=1.08u w=0.7u l=0.5u
X184 ota_cmfb_top_0.ota_cmfb_core_push_pull_output_stage_1/dynamic_pcell$4_0.B_DRN ota_cmfb_top_0.ota_cmfb_core_push_pull_output_stage_1/dynamic_pcell$4_0.B_DRN ota_cmfb_top_0.ota_cmfb_core_push_pull_output_stage_1/dynamic_pcell$4_0.DRN_NET_OP_GATE_MP vss_1v2.t22 sg13_lv_nmos ad=0.133p pd=1.08u as=0.133p ps=1.08u w=0.7u l=3u
X185 ota_cmfb_top_0.dynamic_pcell$5_0.DRN_NET_BD ota_cmfb_top_0.dynamic_pcell$5_0.DRN_NET_E_GATE_CDEFGH vss_1v2.t334 vss_1v2.t317 sg13_lv_nmos ad=62.5f pd=0.74u as=62.5f ps=0.74u w=0.25u l=10u
X186 vdd_1v2.t209 vdd_1v2.t207 vdd_1v2.t208 vdd_1v2.t0 sg13_lv_pmos ad=0.85p pd=5.68u as=0 ps=0 w=2.5u l=0.5u
X187 ota_cmfb_top_0.ota_cmfb_core_push_pull_output_stage_1/dynamic_pcell$4_0.DRN_NET_MENX vss_1v2.t170 vss_1v2.t171 vss_1v2.t29 sg13_lv_nmos ad=0.133p pd=1.08u as=0.133p ps=1.08u w=0.7u l=3u
X188 ota_cmfb_top_0.dynamic_pcell$5_0.DRN_NET_E_GATE_CDEFGH.t5 enable.t2 ibias0 vss_1v2.t54 sg13_lv_nmos ad=0.2516p pd=2.16u as=0.2516p ps=2.16u w=0.74u l=0.13u
X189 vdd_1v2.t33 ota_cmfb_top_0.dynamic_pcell$5_0.DRN_NET_CA s5_an[1] vdd_1v2.t0 sg13_lv_pmos ad=0.17p pd=1.68u as=95f ps=0.88u w=0.5u l=0.5u
X190 vss_1v2.t129 vss_1v2.t131 vss_1v2.t132 vss_1v2.t70 sg13_lv_nmos ad=62.5f pd=0.74u as=0 ps=0 w=0.25u l=0.5u
X191 a_49340_27979# a_49604_27693# vss_1v2.t7 rhigh l=1u w=0.5u
X192 ota_cmfb_top_0.EN_INV_0/sg13cmos5l_inv_4_0.Y enable.t4 vdd_1v2.t402 vdd_1v2.t0 sg13_lv_pmos ad=0.2128p pd=1.5u as=0.3808p ps=2.92u w=1.12u l=0.13u
X193 vdd_1v2.t238 ota_cmfb_top_0.dynamic_pcell$5_0.DRN_NET_JL ota_cmfb_top_0.dynamic_pcell$5_0.SRC_NET_AB vdd_1v2.t0 sg13_lv_pmos ad=0.475p pd=2.88u as=0.475p ps=2.88u w=2.5u l=10u
X194 vdd_1v2.t227 vdd_1v2.t225 vdd_1v2.t226 vdd_1v2.t0 sg13_lv_pmos ad=0.475p pd=2.88u as=0 ps=0 w=2.5u l=0.5u
X195 vss_1v2.t82 vss_1v2.t84 vss_1v2.t85 vss_1v2.t70 sg13_lv_nmos ad=62.5f pd=0.74u as=0 ps=0 w=0.25u l=0.5u
X196 vdd_1v2.t266 vdd_1v2.t258 vdd_1v2.t268 vdd_1v2.t0 sg13_lv_pmos ad=95f pd=0.88u as=0 ps=0 w=0.5u l=0.5u
X197 vss_1v2.t239 vss_1v2.t237 vss_1v2.t236 vss_1v2.t206 sg13_lv_nmos ad=0.133p pd=1.08u as=0 ps=0 w=0.7u l=0.5u
X198 vss_1v2.t143 vss_1v2.t154 vss_1v2.t155 vss_1v2.t97 sg13_lv_nmos ad=0.133p pd=1.08u as=0 ps=0 w=0.7u l=0.5u
X199 vdd_1v2.t99 vdd_1v2.t100 vdd_1v2.t63 vdd_1v2.t0 sg13_lv_pmos ad=0.2375p pd=1.63u as=0 ps=0 w=1.25u l=0.5u
X200 vdd_1v2.t198 vdd_1v2.t196 vdd_1v2.t197 vdd_1v2.t0 sg13_lv_pmos ad=0.85p pd=5.68u as=0 ps=0 w=2.5u l=0.5u
X201 vss_1v2.t320 ota_cmfb_top_0.dynamic_pcell$5_0.Gate ota_cmfb_top_0.dynamic_pcell$5_0.DRN_NET_JL.t4 vss_1v2.t315 sg13_lv_nmos ad=62.5f pd=0.74u as=62.5f ps=0.74u w=0.25u l=10u
X202 vdd_1v2.t470 ota_cmfb_top_0.dynamic_pcell$5_0.DRN_NET_BD s5_an[2] vdd_1v2.t0 sg13_lv_pmos ad=0.17p pd=1.68u as=95f ps=0.88u w=0.5u l=0.5u
X203 ota_cmfb_top_0.dynamic_pcell$5_0.H_DRN.t0 ota_cmfb_top_0.dynamic_pcell$5_0.H_DRN.t4 vdd_1v2.t60 vdd_1v2.t0 sg13_lv_pmos ad=0.2375p pd=1.63u as=0.2375p ps=1.63u w=1.25u l=5u
X204 vdd_1v2.t226 ota_cmfb_top_0.dynamic_pcell$5_0.DRN_NET_JL ota_cmfb_top_0.dynamic_pcell$5_0.SRC_NET_AB vdd_1v2.t0 sg13_lv_pmos ad=0.475p pd=2.88u as=0.475p ps=2.88u w=2.5u l=10u
X205 vdd_1v2.t42 vdd_1v2.t40 vdd_1v2.t0 vdd_1v2.t0 sg13_lv_pmos ad=0.2375p pd=1.63u as=0 ps=0 w=1.25u l=0.5u
X206 ota_cmfb_top_0.dynamic_pcell$5_0.DRN_NET_CA ota_cmfb_top_0.dynamic_pcell$5_0.DRN_NET_E_GATE_CDEFGH vss_1v2.t34 vss_1v2.t315 sg13_lv_nmos ad=62.5f pd=0.74u as=62.5f ps=0.74u w=0.25u l=10u
X207 ota_cmfb_top_0.ota_cmfb_core_push_pull_output_stage_1/dynamic_pcell$4_0.DRN_NET_OP_GATE_MP ota_cmfb_top_0.ota_cmfb_core_push_pull_output_stage_1/dynamic_pcell$4_0.DRN_NET_OP_GATE_MP ota_cmfb_top_0.ota_cmfb_core_push_pull_output_stage_1/dynamic_pcell$4_0.Gate vss_1v2.t29 sg13_lv_nmos ad=0.133p pd=1.08u as=0.133p ps=1.08u w=0.7u l=3u
X208 a_49604_27418# a_49340_27132# vss_1v2.t9 rhigh l=1u w=0.5u
X209 vdd_1v2.t236 vdd_1v2.t234 vdd_1v2.t232 vdd_1v2.t0 sg13_lv_pmos ad=0.475p pd=2.88u as=0 ps=0 w=2.5u l=0.5u
X210 ota_cmfb_top_0.dynamic_pcell$5_0.DRN_NET_BD analog_bus1 ota_cmfb_top_0.dynamic_pcell$5_0.SRC_NET_AB vdd_1v2.t0 sg13_lv_pmos ad=0.475p pd=2.88u as=0.475p ps=2.88u w=2.5u l=2u
X211 ota_cmfb_top_0.EN_INV_1/sg13cmos5l_inv_4_0.Y enable.t3 vdd_1v2.t412 vdd_1v2.t0 sg13_lv_pmos ad=0.2128p pd=1.5u as=0.3808p ps=2.92u w=1.12u l=0.13u
X212 vss_1v2.t256 vss_1v2.t254 vss_1v2.t253 vss_1v2.t206 sg13_lv_nmos ad=0.133p pd=1.08u as=0 ps=0 w=0.7u l=0.5u
X213 vdd_1v2.t462 ota_cmfb_top_0.dynamic_pcell$5_0.DRN_NET_BD s5_an[2] vdd_1v2.t0 sg13_lv_pmos ad=95f pd=0.88u as=95f ps=0.88u w=0.5u l=0.5u
X214 vdd_1v2.t409 enable.t4 ota_cmfb_top_0.EN_INV_0/sg13cmos5l_inv_4_0.Y vdd_1v2.t0 sg13_lv_pmos ad=0.2128p pd=1.5u as=0.2128p ps=1.5u w=1.12u l=0.13u
X215 vdd_1v2.t83 vdd_1v2.t81 vdd_1v2.t80 vdd_1v2.t0 sg13_lv_pmos ad=0.2375p pd=1.63u as=0 ps=0 w=1.25u l=0.5u
X216 vdd_1v2.t255 vdd_1v2.t64 vdd_1v2.t257 vdd_1v2.t0 sg13_lv_pmos ad=95f pd=0.88u as=0 ps=0 w=0.5u l=0.5u
X217 vdd_1v2.t218 vdd_1v2.t216 vdd_1v2.t215 vdd_1v2.t0 sg13_lv_pmos ad=0.475p pd=2.88u as=0 ps=0 w=2.5u l=0.5u
X218 vdd_1v2.t224 vdd_1v2.t222 vdd_1v2.t220 vdd_1v2.t0 sg13_lv_pmos ad=0.475p pd=2.88u as=0 ps=0 w=2.5u l=0.5u
X219 vdd_1v2.t350 vdd_1v2.t348 vdd_1v2.t349 vdd_1v2.t0 sg13_lv_pmos ad=0.85p pd=5.68u as=0 ps=0 w=2.5u l=0.5u
X220 ota_cmfb_top_0.dynamic_pcell$5_0.DRN_NET_BD ota_cmfb_top_0.dynamic_pcell$5_0.DRN_NET_E_GATE_CDEFGH vss_1v2.t34 vss_1v2.t315 sg13_lv_nmos ad=62.5f pd=0.74u as=62.5f ps=0.74u w=0.25u l=10u
X221 vdd_1v2.t60 vdd_1v2.t58 vdd_1v2.t57 vdd_1v2.t0 sg13_lv_pmos ad=0.2375p pd=1.63u as=0 ps=0 w=1.25u l=0.5u
X222 vss_1v2.t139 vss_1v2.t137 vss_1v2.t138 vss_1v2.t66 sg13_lv_nmos ad=0.1075p pd=1.34u as=0 ps=0 w=0.25u l=0.5u
X223 vss_1v2.t18 vss_1v2.t297 vss_1v2.t18 vss_1v2.t301 sg13_lv_nmos ad=95f pd=0.88u as=0 ps=0 w=0.5u l=0.5u
X224 vdd_1v2.t206 vdd_1v2.t204 vdd_1v2.t203 vdd_1v2.t0 sg13_lv_pmos ad=0.475p pd=2.88u as=0 ps=0 w=2.5u l=0.5u
X225 vss_1v2.t92 vss_1v2.t90 vss_1v2.t91 vss_1v2.t66 sg13_lv_nmos ad=0.1075p pd=1.34u as=0 ps=0 w=0.25u l=0.5u
X226 vdd_1v2.t244 vdd_1v2.t64 vdd_1v2.t66 vdd_1v2.t0 sg13_lv_pmos ad=95f pd=0.88u as=0 ps=0 w=0.5u l=0.5u
X227 vdd_1v2.t347 vdd_1v2.t345 vdd_1v2.t328 vdd_1v2.t0 sg13_lv_pmos ad=0.475p pd=2.88u as=0 ps=0 w=2.5u l=0.5u
X228 vdd_1v2.t95 vdd_1v2.t96 vdd_1v2.t97 vdd_1v2.t0 sg13_lv_pmos ad=0.2375p pd=1.63u as=0 ps=0 w=1.25u l=0.5u
X229 ota_cmfb_top_0.dynamic_pcell$5_0.SRC_NET_AB analog_bus0 ota_cmfb_top_0.dynamic_pcell$5_0.DRN_NET_CA vdd_1v2.t0 sg13_lv_pmos ad=0.475p pd=2.88u as=0.475p ps=2.88u w=2.5u l=2u
X230 a_58930_34440# a_58666_34154# vss_1v2.t14 rhigh l=1u w=0.5u
X231 vdd_1v2.t337 vdd_1v2.t335 vdd_1v2.t336 vdd_1v2.t0 sg13_lv_pmos ad=0.85p pd=5.68u as=0 ps=0 w=2.5u l=0.5u
X232 ota_cmfb_top_0.dynamic_pcell$5_0.DRN_NET_E_GATE_CDEFGH.t4 ota_cmfb_top_0.EN_INV_1/sg13cmos5l_inv_4_0.Y vss_1v2.t42 vss_1v2.t41 sg13_lv_nmos ad=0.2516p pd=2.16u as=0.2516p ps=2.16u w=0.74u l=0.13u
X233 vss_1v2.t145 vss_1v2.t146 vss_1v2.t145 vss_1v2.t80 sg13_lv_nmos ad=62.5f pd=0.74u as=0 ps=0 w=0.25u l=0.5u
X234 vdd_1v2.t369 vdd_1v2.t367 vdd_1v2.t368 vdd_1v2.t0 sg13_lv_pmos ad=0.85p pd=5.68u as=0 ps=0 w=2.5u l=0.5u
X235 a_51669_34440# a_51669_33917# vss_1v2.t8 rhigh l=1u w=0.5u
X236 ota_cmfb_top_0.dynamic_pcell$5_0.SRC_NET_AB analog_bus1 ota_cmfb_top_0.dynamic_pcell$5_0.DRN_NET_BD vdd_1v2.t0 sg13_lv_pmos ad=0.475p pd=2.88u as=0.475p ps=2.88u w=2.5u l=2u
X237 vdd_1v2.t441 ota_cmfb_top_0.dynamic_pcell$5_0.F_DRN ota_cmfb_top_0.ota_cmfb_core_push_pull_output_stage_0/dynamic_pcell$4_0.DRN_NET_CD vdd_1v2.t0 sg13_lv_pmos ad=0.475p pd=2.88u as=0.475p ps=2.88u w=2.5u l=3u
X238 vss_1v2.t78 vss_1v2.t104 vss_1v2.t105 vss_1v2.t80 sg13_lv_nmos ad=62.5f pd=0.74u as=0 ps=0 w=0.25u l=0.5u
X239 vdd_1v2.t37 vdd_1v2.t36 ota_cmfb_top_0.dynamic_pcell$5_0.SRC_NET_AB vdd_1v2.t0 sg13_lv_pmos ad=0.475p pd=2.88u as=0.475p ps=2.88u w=2.5u l=0.5u
X240 ota_cmfb_top_0.dynamic_pcell$5_0.DRN_NET_BD ota_cmfb_top_0.dynamic_pcell$5_0.DRN_NET_E_GATE_CDEFGH vss_1v2.t34 vss_1v2.t315 sg13_lv_nmos ad=62.5f pd=0.74u as=62.5f ps=0.74u w=0.25u l=10u
X241 vdd_1v2.t356 vdd_1v2.t354 vdd_1v2.t355 vdd_1v2.t0 sg13_lv_pmos ad=0.85p pd=5.68u as=0 ps=0 w=2.5u l=0.5u
X242 ota_cmfb_top_0.ota_cmfb_core_push_pull_output_stage_1/dynamic_pcell$4_0.DRN_NET_CD vdd_1v2.t343 vdd_1v2.t325 vdd_1v2.t0 sg13_lv_pmos ad=0.475p pd=2.88u as=0.475p ps=2.88u w=2.5u l=0.5u
X243 ota_cmfb_top_0.dynamic_pcell$5_0.SRC_NET_AB ota_cmfb_top_0.dynamic_pcell$5_0.DRN_NET_JL vdd_1v2.t212 vdd_1v2.t0 sg13_lv_pmos ad=0.475p pd=2.88u as=0.475p ps=2.88u w=2.5u l=10u
X244 ota_cmfb_top_0.ota_cmfb_core_push_pull_output_stage_0/dynamic_pcell$4_0.Gate ota_cmfb_top_0.ota_cmfb_core_push_pull_output_stage_0/dynamic_pcell$4_0.DRN_NET_OP_GATE_MP ota_cmfb_top_0.ota_cmfb_core_push_pull_output_stage_0/dynamic_pcell$4_0.DRN_NET_OP_GATE_MP vss_1v2.t4 sg13_lv_nmos ad=0.133p pd=1.08u as=0.133p ps=1.08u w=0.7u l=3u
X245 vss_1v2.t56 enable.t0 ota_cmfb_top_0.ota_cmfb_core_push_pull_output_stage_0/EN_INV_0/sg13cmos5l_inv_4_0.Y vss_1v2.t64 sg13_lv_nmos ad=0.2516p pd=2.16u as=0.1406p ps=1.12u w=0.74u l=0.13u
X246 vss_1v2.t200 vss_1v2.t198 vss_1v2.t189 vss_1v2.t97 sg13_lv_nmos ad=0.133p pd=1.08u as=0 ps=0 w=0.7u l=0.5u
X247 ota_cmfb_top_0.dynamic_pcell$5_0.SRC_NET_AB vdd_1v2.t34 vdd_1v2.t35 vdd_1v2.t0 sg13_lv_pmos ad=0.475p pd=2.88u as=0.475p ps=2.88u w=2.5u l=0.5u
X248 ota_cmfb_top_0.ota_cmfb_core_push_pull_output_stage_0/dynamic_pcell$4_0.DRN_NET_J_GATE_EJ ota_cmfb_top_0.ota_cmfb_core_push_pull_output_stage_0/dynamic_pcell$4_0.Gate vss_1v2.t349 vss_1v2.t5 sg13_lv_nmos ad=0.133p pd=1.08u as=0.133p ps=1.08u w=0.7u l=3u
X249 ota_cmfb_top_0.ota_cmfb_core_push_pull_output_stage_1/dynamic_pcell$4_0.DRN_NET_OP_GATE_MP vss_1v2.t159 vss_1v2.t157 vss_1v2.t153 sg13_lv_nmos ad=0.133p pd=1.08u as=0.133p ps=1.08u w=0.7u l=0.5u
X250 vss_1v2.t108 vss_1v2.t106 vss_1v2.t76 vss_1v2.t66 sg13_lv_nmos ad=0.1075p pd=1.34u as=0 ps=0 w=0.25u l=0.5u
X251 a_50396_27979# a_50660_27693# vss_1v2.t10 rhigh l=1u w=0.5u
X252 vdd_1v2.t77 vdd_1v2.t75 vdd_1v2.t74 vdd_1v2.t0 sg13_lv_pmos ad=0.2375p pd=1.63u as=0 ps=0 w=1.25u l=0.5u
X253 vdd_1v2.t251 vdd_1v2.t64 vdd_1v2.t253 vdd_1v2.t0 sg13_lv_pmos ad=95f pd=0.88u as=0 ps=0 w=0.5u l=0.5u
X254 ota_cmfb_top_0.ota_cmfb_core_push_pull_output_stage_0/dynamic_pcell$4_0.Gate ota_cmfb_top_0.ota_cmfb_core_push_pull_output_stage_0/EN_INV_0/sg13cmos5l_inv_4_0.Y vss_1v2.t39 vss_1v2.t38 sg13_lv_nmos ad=0.2516p pd=2.16u as=0.2516p ps=2.16u w=0.74u l=0.13u
X255 a_51933_33917# a_51669_33631# vss_1v2.t8 rhigh l=1u w=0.5u
X256 a_49868_27979# a_49604_27693# vss_1v2.t10 rhigh l=1u w=0.5u
X257 a_58930_34440# w_59515_33612# vss_1v2.t15 rhigh l=1u w=0.5u
X258 ota_cmfb_top_0.dynamic_pcell$5_0.SRC_NET_AB ota_cmfb_top_0.dynamic_pcell$5_0.DRN_NET_JL vdd_1v2.t200 vdd_1v2.t0 sg13_lv_pmos ad=0.475p pd=2.88u as=0.475p ps=2.88u w=2.5u l=10u
X259 ota_cmfb_top_0.ota_cmfb_core_push_pull_output_stage_0/dynamic_pcell$4_0.DRN_NET_CD ota_cmfb_top_0.dynamic_pcell$5_0.F_DRN vdd_1v2.t441 vdd_1v2.t0 sg13_lv_pmos ad=0.475p pd=2.88u as=0.475p ps=2.88u w=2.5u l=3u
X260 vdd_1v2.t375 vdd_1v2.t373 vdd_1v2.t374 vdd_1v2.t0 sg13_lv_pmos ad=0.85p pd=5.68u as=0 ps=0 w=2.5u l=0.5u
X261 vss_1v2.t110 vss_1v2.t109 vss_1v2.t110 vss_1v2.t80 sg13_lv_nmos ad=62.5f pd=0.74u as=0 ps=0 w=0.25u l=0.5u
X262 ota_cmfb_top_0.dynamic_pcell$5_0.Gate ota_cmfb_top_0.EN_INV_0/sg13cmos5l_inv_4_0.Y vss_1v2.t313 vss_1v2.t41 sg13_lv_nmos ad=0.2516p pd=2.16u as=0.2516p ps=2.16u w=0.74u l=0.13u
X263 ota_cmfb_top_0.dynamic_pcell$5_0.DRN_NET_CA ota_cmfb_top_0.dynamic_pcell$5_0.DRN_NET_E_GATE_CDEFGH vss_1v2.t34 vss_1v2.t315 sg13_lv_nmos ad=62.5f pd=0.74u as=62.5f ps=0.74u w=0.25u l=10u
X264 vss_1v2.t228 vss_1v2.t227 ota_cmfb_top_0.ota_cmfb_core_push_pull_output_stage_0/dynamic_pcell$4_0.DRN_NET_MENX vss_1v2.t4 sg13_lv_nmos ad=0.133p pd=1.08u as=0.133p ps=1.08u w=0.7u l=3u
X265 vss_1v2.t18 vss_1v2.t297 vss_1v2.t18 vss_1v2.t298 sg13_lv_nmos ad=0.17p pd=1.68u as=0 ps=0 w=0.5u l=0.5u
X266 a_50660_27418# a_50396_27132# vss_1v2.t324 rhigh l=1u w=0.5u
X267 ota_cmfb_top_0.ota_cmfb_core_push_pull_output_stage_1/dynamic_pcell$4_0.DRN_NET_MENX vss_1v2.t164 vss_1v2.t162 vss_1v2.t153 sg13_lv_nmos ad=0.133p pd=1.08u as=0.133p ps=1.08u w=0.7u l=0.5u
X268 ota_cmfb_top_0.dynamic_pcell$5_0.SRC_NET_AB analog_bus1 ota_cmfb_top_0.dynamic_pcell$5_0.DRN_NET_BD vdd_1v2.t0 sg13_lv_pmos ad=0.85p pd=5.68u as=0.475p ps=2.88u w=2.5u l=2u
X269 vss_1v2.t95 vss_1v2.t93 vss_1v2.t94 vss_1v2.t66 sg13_lv_nmos ad=0.1075p pd=1.34u as=0 ps=0 w=0.25u l=0.5u
X270 a_48812_27979# ota_cmfb_top_0.dynamic_pcell$5_0.L_GATE vss_1v2.t36 rhigh l=1u w=0.5u
X271 ota_cmfb_top_0.ota_cmfb_core_push_pull_output_stage_1/EN_INV_0/sg13cmos5l_inv_4_0.Y enable.t1 vss_1v2.t58 vss_1v2.t57 sg13_lv_nmos ad=0.1406p pd=1.12u as=0.2516p ps=2.16u w=0.74u l=0.13u
X272 vdd_1v2.t283 vdd_1v2.t284 vdd_1v2.t285 vdd_1v2.t0 sg13_lv_pmos ad=0.475p pd=2.88u as=0 ps=0 w=2.5u l=0.5u
X273 vdd_1v2.t54 vdd_1v2.t52 vdd_1v2.t51 vdd_1v2.t0 sg13_lv_pmos ad=0.2375p pd=1.63u as=0 ps=0 w=1.25u l=0.5u
X274 vdd_1v2.t421 enable.t0 ota_cmfb_top_0.ota_cmfb_core_push_pull_output_stage_0/EN_INV_0/sg13cmos5l_inv_4_0.Y vdd_1v2.t0 sg13_lv_pmos ad=0.3808p pd=2.92u as=0.2128p ps=1.5u w=1.12u l=0.13u
X275 a_49604_27418# a_49868_27132# vss_1v2.t361 rhigh l=1u w=0.5u
X276 vss_1v2.t18 ota_cmfb_top_0.ota_cmfb_core_push_pull_output_stage_0/dynamic_pcell$4_0.DRN_NET_MENX s5_an[2] vss_1v2.t17 sg13_lv_nmos ad=0.17p pd=1.68u as=0.17p ps=1.68u w=0.5u l=10u
X277 a_51933_33917# a_52197_33631# vss_1v2.t16 rhigh l=1u w=0.5u
X278 vss_1v2.t286 vss_1v2.t284 vss_1v2.t286 vss_1v2.t293 sg13_lv_nmos ad=95f pd=0.88u as=0 ps=0 w=0.5u l=0.5u
X279 ota_cmfb_top_0.ota_cmfb_core_push_pull_output_stage_0/dynamic_pcell$4_0.B_DRN ota_cmfb_top_0.dynamic_pcell$5_0.F_DRN vdd_1v2.t353 vdd_1v2.t0 sg13_lv_pmos ad=0.475p pd=2.88u as=0.475p ps=2.88u w=2.5u l=3u
X280 vss_1v2.t116 vss_1v2.t115 vss_1v2.t116 vss_1v2.t80 sg13_lv_nmos ad=62.5f pd=0.74u as=0 ps=0 w=0.25u l=0.5u
X281 ota_cmfb_top_0.dynamic_pcell$5_0.DRN_NET_BD analog_bus1 ota_cmfb_top_0.dynamic_pcell$5_0.SRC_NET_AB vdd_1v2.t0 sg13_lv_pmos ad=0.475p pd=2.88u as=0.475p ps=2.88u w=2.5u l=2u
X282 ota_cmfb_top_0.ota_cmfb_core_push_pull_output_stage_0/dynamic_pcell$4_0.B_DRN ota_cmfb_top_0.ota_cmfb_core_push_pull_output_stage_0/dynamic_pcell$4_0.B_DRN ota_cmfb_top_0.ota_cmfb_core_push_pull_output_stage_0/dynamic_pcell$4_0.DRN_NET_OP_GATE_MP vss_1v2.t4 sg13_lv_nmos ad=0.133p pd=1.08u as=0.133p ps=1.08u w=0.7u l=3u
X283 vss_1v2.t246 vss_1v2.t246 vss_1v2.t246 vss_1v2.t268 sg13_lv_nmos ad=95f pd=0.88u as=0 ps=0 w=0.5u l=0.5u
X284 vdd_1v2.t1 vdd_1v2.t278 vdd_1v2.t276 vdd_1v2.t0 sg13_lv_pmos ad=0.475p pd=2.88u as=0 ps=0 w=2.5u l=0.5u
X285 ota_cmfb_top_0.dynamic_pcell$5_0.SRC_NET_KL.t6 ota_cmfb_top_0.dynamic_pcell$5_0.H_DRN vdd_1v2.t23 vdd_1v2.t0 sg13_lv_pmos ad=0.2375p pd=1.63u as=0.2375p ps=1.63u w=1.25u l=5u
X286 ota_cmfb_top_0.EN_INV_0/sg13cmos5l_inv_4_0.Y enable.t4 vss_1v2.t46 vss_1v2.t45 sg13_lv_nmos ad=0.1406p pd=1.12u as=0.2516p ps=2.16u w=0.74u l=0.13u
X287 vdd_1v2.t305 vdd_1v2.t303 vdd_1v2.t302 vdd_1v2.t0 sg13_lv_pmos ad=0.475p pd=2.88u as=0 ps=0 w=2.5u l=0.5u
X288 vdd_1v2.t163 vdd_1v2.t161 vdd_1v2.t147 vdd_1v2.t0 sg13_lv_pmos ad=0.475p pd=2.88u as=0 ps=0 w=2.5u l=0.5u
X289 vss_1v2.t18 vss_1v2.t297 vss_1v2.t18 vss_1v2.t305 sg13_lv_nmos ad=95f pd=0.88u as=0 ps=0 w=0.5u l=0.5u
X290 ota_cmfb_top_0.dynamic_pcell$5_0.DRN_NET_CA analog_bus0 ota_cmfb_top_0.dynamic_pcell$5_0.SRC_NET_AB vdd_1v2.t0 sg13_lv_pmos ad=0.475p pd=2.88u as=0.475p ps=2.88u w=2.5u l=2u
X291 ota_cmfb_top_0.ota_cmfb_core_push_pull_output_stage_1/dynamic_pcell$4_0.DRN_NET_OP_GATE_MP vss_1v2.t182 vss_1v2.t181 vss_1v2.t153 sg13_lv_nmos ad=0.133p pd=1.08u as=0.133p ps=1.08u w=0.7u l=0.5u
X292 vss_1v2.t316 ota_cmfb_top_0.dynamic_pcell$5_0.Gate ota_cmfb_top_0.dynamic_pcell$5_0.Gate vss_1v2.t315 sg13_lv_nmos ad=62.5f pd=0.74u as=62.5f ps=0.74u w=0.25u l=10u
X293 vdd_1v2.t315 vdd_1v2.t313 vdd_1v2.t307 vdd_1v2.t0 sg13_lv_pmos ad=0.475p pd=2.88u as=0 ps=0 w=2.5u l=0.5u
X294 ota_cmfb_top_0.dynamic_pcell$5_0.L_GATE a_48812_27132# vss_1v2.t310 rhigh l=1u w=0.5u
X295 vdd_1v2.t132 vdd_1v2.t142 vdd_1v2.t143 vdd_1v2.t0 sg13_lv_pmos ad=0.475p pd=2.88u as=0 ps=0 w=2.5u l=0.5u
X296 vss_1v2.t121 vss_1v2.t119 vss_1v2.t120 vss_1v2.t66 sg13_lv_nmos ad=0.1075p pd=1.34u as=0 ps=0 w=0.25u l=0.5u
X297 a_48812_27979# a_49076_27693# vss_1v2.t37 rhigh l=1u w=0.5u
X298 vdd_1v2.t293 vdd_1v2.t291 vdd_1v2.t292 vdd_1v2.t0 sg13_lv_pmos ad=0.475p pd=2.88u as=0 ps=0 w=2.5u l=0.5u
X299 ota_cmfb_top_0.dynamic_pcell$5_0.DRN_NET_BD ota_cmfb_top_0.ota_cmfb_core_push_pull_output_stage_0/dynamic_pcell$4_0.DRN_NET_J_GATE_EJ ota_cmfb_top_0.ota_cmfb_core_push_pull_output_stage_0/dynamic_pcell$4_0.DRN_NET_MENX vdd_1v2.t0 sg13_lv_pmos ad=0.85p pd=5.68u as=0.475p ps=2.88u w=2.5u l=3u
X300 vdd_1v2.t264 vdd_1v2.t258 vdd_1v2.t266 vdd_1v2.t0 sg13_lv_pmos ad=95f pd=0.88u as=0 ps=0 w=0.5u l=0.5u
X301 vdd_1v2.t443 ota_cmfb_top_0.dynamic_pcell$5_0.F_DRN ota_cmfb_top_0.dynamic_pcell$5_0.F_DRN.t0 vdd_1v2.t0 sg13_lv_pmos ad=0.475p pd=2.88u as=0.475p ps=2.88u w=2.5u l=3u
X302 vss_1v2.t143 vss_1v2.t142 ota_cmfb_top_0.ota_cmfb_core_push_pull_output_stage_1/dynamic_pcell$4_0.SRC_NET_ML vss_1v2.t101 sg13_lv_nmos ad=0.133p pd=1.08u as=0.133p ps=1.08u w=0.7u l=0.5u
X303 ota_cmfb_top_0.ota_cmfb_core_push_pull_output_stage_1/dynamic_pcell$4_0.DRN_NET_MENX vdd_1v2.t299 vdd_1v2.t295 vdd_1v2.t0 sg13_lv_pmos ad=0.475p pd=2.88u as=0.475p ps=2.88u w=2.5u l=0.5u
X304 ota_cmfb_top_0.ota_cmfb_core_push_pull_output_stage_1/EN_INV_0/sg13cmos5l_inv_4_0.Y enable.t1 vdd_1v2.t406 vdd_1v2.t0 sg13_lv_pmos ad=0.2128p pd=1.5u as=0.3808p ps=2.92u w=1.12u l=0.13u
X305 vdd_1v2.t432 ota_cmfb_top_0.dynamic_pcell$5_0.F_DRN ota_cmfb_top_0.ota_cmfb_core_push_pull_output_stage_0/dynamic_pcell$4_0.B_DRN vdd_1v2.t0 sg13_lv_pmos ad=0.85p pd=5.68u as=0.475p ps=2.88u w=2.5u l=3u
X306 ota_cmfb_top_0.dynamic_pcell$5_0.G_DRN.t0 vdd_1v2.t311 vdd_1v2.t309 vdd_1v2.t0 sg13_lv_pmos ad=0.475p pd=2.88u as=0.475p ps=2.88u w=2.5u l=0.5u
X307 vss_1v2.t125 vss_1v2.t126 vss_1v2.t125 vss_1v2.t80 sg13_lv_nmos ad=62.5f pd=0.74u as=0 ps=0 w=0.25u l=0.5u
X308 ota_cmfb_top_0.ota_cmfb_core_push_pull_output_stage_0/dynamic_pcell$4_0.SRC_NET_ML ota_cmfb_top_0.ota_cmfb_core_push_pull_output_stage_0/dynamic_pcell$4_0.DRN_NET_OP_GATE_MP ota_cmfb_top_0.ota_cmfb_core_push_pull_output_stage_0/dynamic_pcell$4_0.DRN_NET_MENX vss_1v2.t5 sg13_lv_nmos ad=0.133p pd=1.08u as=0.133p ps=1.08u w=0.7u l=3u
X309 ota_cmfb_top_0.ota_cmfb_core_push_pull_output_stage_0/dynamic_pcell$4_0.DRN_NET_HI ota_cmfb_top_0.dynamic_pcell$5_0.F_DRN vdd_1v2.t359 vdd_1v2.t0 sg13_lv_pmos ad=0.475p pd=2.88u as=0.475p ps=2.88u w=2.5u l=3u
X310 vss_1v2.t320 ota_cmfb_top_0.dynamic_pcell$5_0.DRN_NET_E_GATE_CDEFGH ota_cmfb_top_0.dynamic_pcell$5_0.DRN_NET_BD vss_1v2.t315 sg13_lv_nmos ad=62.5f pd=0.74u as=62.5f ps=0.74u w=0.25u l=10u
X311 s5_an[2] ota_cmfb_top_0.dynamic_pcell$5_0.DRN_NET_BD vdd_1v2.t468 vdd_1v2.t0 sg13_lv_pmos ad=95f pd=0.88u as=95f ps=0.88u w=0.5u l=0.5u
X312 ota_cmfb_top_0.dynamic_pcell$5_0.SRC_NET_KL.t7 ota_cmfb_top_0.dynamic_pcell$5_0.H_DRN vdd_1v2.t458 vdd_1v2.t0 sg13_lv_pmos ad=0.2375p pd=1.63u as=0.2375p ps=1.63u w=1.25u l=5u
X313 vdd_1v2.t3 vdd_1v2.t289 vdd_1v2.t287 vdd_1v2.t0 sg13_lv_pmos ad=0.475p pd=2.88u as=0 ps=0 w=2.5u l=0.5u
X314 vss_1v2.t334 ota_cmfb_top_0.dynamic_pcell$5_0.DRN_NET_E_GATE_CDEFGH ota_cmfb_top_0.dynamic_pcell$5_0.DRN_NET_CA vss_1v2.t315 sg13_lv_nmos ad=62.5f pd=0.74u as=62.5f ps=0.74u w=0.25u l=10u
X315 ota_cmfb_top_0.EN_INV_1/sg13cmos5l_inv_4_0.Y enable.t3 vss_1v2.t47 vss_1v2.t45 sg13_lv_nmos ad=0.1406p pd=1.12u as=0.2516p ps=2.16u w=0.74u l=0.13u
X316 vdd_1v2.t48 vdd_1v2.t46 vdd_1v2.t45 vdd_1v2.t0 sg13_lv_pmos ad=0.2375p pd=1.63u as=0 ps=0 w=1.25u l=0.5u
X317 vdd_1v2.t323 vdd_1v2.t321 vdd_1v2.t281 vdd_1v2.t0 sg13_lv_pmos ad=0.475p pd=2.88u as=0 ps=0 w=2.5u l=0.5u
X318 a_49076_27418# a_48812_27132# vss_1v2.t362 rhigh l=1u w=0.5u
X319 vss_1v2.t12 ota_cmfb_top_0.ota_cmfb_core_push_pull_output_stage_1/dynamic_pcell$4_0.DRN_NET_MENX s5_an[1] vss_1v2.t11 sg13_lv_nmos ad=0.17p pd=1.68u as=0.17p ps=1.68u w=0.5u l=10u
X320 vss_1v2.t46 enable.t4 ota_cmfb_top_0.EN_INV_0/sg13cmos5l_inv_4_0.Y vss_1v2.t45 sg13_lv_nmos ad=0.1406p pd=1.12u as=0.1406p ps=1.12u w=0.74u l=0.13u
X321 vss_1v2.t99 vss_1v2.t96 vss_1v2.t98 vss_1v2.t97 sg13_lv_nmos ad=0.133p pd=1.08u as=0 ps=0 w=0.7u l=0.5u
X322 vss_1v2.t204 vss_1v2.t201 vss_1v2.t203 vss_1v2.t202 sg13_lv_nmos ad=0.238p pd=2.08u as=0 ps=0 w=0.7u l=0.5u
X323 vss_1v2.t68 vss_1v2.t65 vss_1v2.t67 vss_1v2.t66 sg13_lv_nmos ad=0.1075p pd=1.34u as=0 ps=0 w=0.25u l=0.5u
X324 ota_cmfb_top_0.dynamic_pcell$5_0.F_DRN.t10 ota_cmfb_top_0.dynamic_pcell$5_0.F_DRN vdd_1v2.t443 vdd_1v2.t0 sg13_lv_pmos ad=0.475p pd=2.88u as=0.475p ps=2.88u w=2.5u l=3u
X325 s5_an[1] ota_cmfb_top_0.dynamic_pcell$5_0.DRN_NET_CA vdd_1v2.t25 vdd_1v2.t0 sg13_lv_pmos ad=95f pd=0.88u as=95f ps=0.88u w=0.5u l=0.5u
X326 vss_1v2.t286 vss_1v2.t284 vss_1v2.t286 vss_1v2.t289 sg13_lv_nmos ad=95f pd=0.88u as=0 ps=0 w=0.5u l=0.5u
X327 s5_an[2] ota_cmfb_top_0.dynamic_pcell$5_0.DRN_NET_BD vdd_1v2.t461 vdd_1v2.t0 sg13_lv_pmos ad=95f pd=0.88u as=0.17p ps=1.68u w=0.5u l=0.5u
X328 ota_cmfb_top_0.ota_cmfb_core_push_pull_output_stage_0/dynamic_pcell$4_0.DRN_NET_J_GATE_EJ ota_cmfb_top_0.ota_cmfb_core_push_pull_output_stage_0/dynamic_pcell$4_0.DRN_NET_J_GATE_EJ ota_cmfb_top_0.ota_cmfb_core_push_pull_output_stage_0/dynamic_pcell$4_0.SRC_NET_IJ_GATE_DI vdd_1v2.t0 sg13_lv_pmos ad=0.475p pd=2.88u as=0.475p ps=2.88u w=2.5u l=3u
X329 vdd_1v2.t272 vdd_1v2.t258 vdd_1v2.t274 vdd_1v2.t0 sg13_lv_pmos ad=95f pd=0.88u as=0 ps=0 w=0.5u l=0.5u
X330 vss_1v2.t246 vss_1v2.t246 vss_1v2.t246 vss_1v2.t247 sg13_lv_nmos ad=95f pd=0.88u as=0 ps=0 w=0.5u l=0.5u
X331 vdd_1v2.t253 vdd_1v2.t64 vdd_1v2.t255 vdd_1v2.t0 sg13_lv_pmos ad=95f pd=0.88u as=0 ps=0 w=0.5u l=0.5u
X332 vss_1v2.t12 vss_1v2.t12 vss_1v2.t12 vss_1v2.t280 sg13_lv_nmos ad=95f pd=0.88u as=0 ps=0 w=0.5u l=0.5u
X333 vdd_1v2.t130 vdd_1v2.t128 vdd_1v2.t129 vdd_1v2.t0 sg13_lv_pmos ad=0.85p pd=5.68u as=0 ps=0 w=2.5u l=0.5u
X334 vdd_1v2.t437 ota_cmfb_top_0.dynamic_pcell$5_0.F_DRN ota_cmfb_top_0.ota_cmfb_core_push_pull_output_stage_0/dynamic_pcell$4_0.DRN_NET_HI vdd_1v2.t0 sg13_lv_pmos ad=0.85p pd=5.68u as=0.475p ps=2.88u w=2.5u l=3u
X335 ota_cmfb_top_0.ota_cmfb_core_push_pull_output_stage_1/dynamic_pcell$4_0.SRC_NET_IJ_GATE_DI vdd_1v2.t319 vdd_1v2.t317 vdd_1v2.t0 sg13_lv_pmos ad=0.475p pd=2.88u as=0.475p ps=2.88u w=2.5u l=0.5u
X336 vdd_1v2.t172 vdd_1v2.t153 vdd_1v2.t157 vdd_1v2.t0 sg13_lv_pmos ad=95f pd=0.88u as=0 ps=0 w=0.5u l=0.5u
X337 vss_1v2.t74 vss_1v2.t79 vss_1v2.t74 vss_1v2.t80 sg13_lv_nmos ad=62.5f pd=0.74u as=0 ps=0 w=0.25u l=0.5u
X338 ota_cmfb_top_0.ota_cmfb_core_push_pull_output_stage_0/dynamic_pcell$4_0.SRC_NET_ML ota_cmfb_top_0.ota_cmfb_core_push_pull_output_stage_0/dynamic_pcell$4_0.DRN_NET_OP_GATE_MP ota_cmfb_top_0.ota_cmfb_core_push_pull_output_stage_0/dynamic_pcell$4_0.DRN_NET_MENX vss_1v2.t1 sg13_lv_nmos ad=0.133p pd=1.08u as=0.133p ps=1.08u w=0.7u l=3u
X339 vdd_1v2.t182 vdd_1v2.t177 vdd_1v2.t178 vdd_1v2.t0 sg13_lv_pmos ad=95f pd=0.88u as=0 ps=0 w=0.5u l=0.5u
X340 vss_1v2.t130 vss_1v2.t128 vss_1v2.t129 vss_1v2.t66 sg13_lv_nmos ad=0.1075p pd=1.34u as=0 ps=0 w=0.25u l=0.5u
X341 ota_cmfb_top_0.ota_cmfb_core_push_pull_output_stage_1/dynamic_pcell$4_0.DRN_NET_CD ota_cmfb_top_0.dynamic_pcell$5_0.G_DRN vdd_1v2.t19 vdd_1v2.t0 sg13_lv_pmos ad=0.475p pd=2.88u as=0.475p ps=2.88u w=2.5u l=3u
X342 vss_1v2.t178 vss_1v2.t176 vss_1v2.t175 vss_1v2.t97 sg13_lv_nmos ad=0.133p pd=1.08u as=0 ps=0 w=0.7u l=0.5u
X343 vss_1v2.t83 vss_1v2.t81 vss_1v2.t82 vss_1v2.t66 sg13_lv_nmos ad=0.1075p pd=1.34u as=0 ps=0 w=0.25u l=0.5u
X344 vdd_1v2.t22 vdd_1v2.t327 vdd_1v2.t328 vdd_1v2.t0 sg13_lv_pmos ad=0.475p pd=2.88u as=0 ps=0 w=2.5u l=0.5u
X345 ota_cmfb_top_0.ota_cmfb_core_push_pull_output_stage_0/dynamic_pcell$4_0.SRC_NET_ML ota_cmfb_top_0.ota_cmfb_core_push_pull_output_stage_0/dynamic_pcell$4_0.Gate vss_1v2.t349 vss_1v2.t3 sg13_lv_nmos ad=0.133p pd=1.08u as=0.133p ps=1.08u w=0.7u l=3u
X346 vdd_1v2.t93 vdd_1v2.t94 vdd_1v2.t95 vdd_1v2.t0 sg13_lv_pmos ad=0.2375p pd=1.63u as=0 ps=0 w=1.25u l=0.5u
X347 ota_cmfb_top_0.ota_cmfb_core_push_pull_output_stage_0/dynamic_pcell$4_0.SRC_NET_IJ_GATE_DI ota_cmfb_top_0.ota_cmfb_core_push_pull_output_stage_0/dynamic_pcell$4_0.DRN_NET_J_GATE_EJ ota_cmfb_top_0.ota_cmfb_core_push_pull_output_stage_0/dynamic_pcell$4_0.DRN_NET_J_GATE_EJ vdd_1v2.t0 sg13_lv_pmos ad=0.475p pd=2.88u as=0.475p ps=2.88u w=2.5u l=3u
X348 s5_an[1] ota_cmfb_top_0.dynamic_pcell$5_0.DRN_NET_CA vdd_1v2.t29 vdd_1v2.t0 sg13_lv_pmos ad=95f pd=0.88u as=95f ps=0.88u w=0.5u l=0.5u
X349 vss_1v2.t151 vss_1v2.t148 vss_1v2.t150 vss_1v2.t149 sg13_lv_nmos ad=0.238p pd=2.08u as=0 ps=0 w=0.7u l=0.5u
X350 vdd_1v2.t401 enable.t3 ota_cmfb_top_0.EN_INV_1/sg13cmos5l_inv_4_0.Y vdd_1v2.t0 sg13_lv_pmos ad=0.2128p pd=1.5u as=0.2128p ps=1.5u w=1.12u l=0.13u
X351 ota_cmfb_top_0.dynamic_pcell$5_0.SRC_NET_AB analog_bus1 ota_cmfb_top_0.dynamic_pcell$5_0.DRN_NET_BD vdd_1v2.t0 sg13_lv_pmos ad=0.475p pd=2.88u as=0.475p ps=2.88u w=2.5u l=2u
X352 ota_cmfb_top_0.ota_cmfb_core_push_pull_output_stage_1/dynamic_pcell$4_0.DRN_NET_MENX ota_cmfb_top_0.ota_cmfb_core_push_pull_output_stage_1/dynamic_pcell$4_0.DRN_NET_OP_GATE_MP ota_cmfb_top_0.ota_cmfb_core_push_pull_output_stage_1/dynamic_pcell$4_0.SRC_NET_ML vss_1v2.t27 sg13_lv_nmos ad=0.133p pd=1.08u as=0.133p ps=1.08u w=0.7u l=3u
X353 vss_1v2.t134 vss_1v2.t135 vss_1v2.t136 vss_1v2.t80 sg13_lv_nmos ad=62.5f pd=0.74u as=0 ps=0 w=0.25u l=0.5u
X354 vdd_1v2.t435 ota_cmfb_top_0.dynamic_pcell$5_0.F_DRN ota_cmfb_top_0.dynamic_pcell$5_0.F_DRN.t4 vdd_1v2.t0 sg13_lv_pmos ad=0.475p pd=2.88u as=0.85p ps=5.68u w=2.5u l=3u
X355 vss_1v2.t246 vss_1v2.t246 vss_1v2.t246 vss_1v2.t272 sg13_lv_nmos ad=95f pd=0.88u as=0 ps=0 w=0.5u l=0.5u
X356 ota_cmfb_top_0.EN_INV_0/sg13cmos5l_inv_4_0.Y enable.t4 vdd_1v2.t409 vdd_1v2.t0 sg13_lv_pmos ad=0.2128p pd=1.5u as=0.2128p ps=1.5u w=1.12u l=0.13u
X357 a_51669_34440# a_51933_34154# vss_1v2.t8 rhigh l=1u w=0.5u
X358 ota_cmfb_top_0.dynamic_pcell$5_0.Gate s5_an[0] ota_cmfb_top_0.dynamic_pcell$5_0.SRC_NET_KL.t0 vdd_1v2.t0 sg13_lv_pmos ad=0.475p pd=2.88u as=0.85p ps=5.68u w=2.5u l=2u
X359 ota_cmfb_top_0.ota_cmfb_core_push_pull_output_stage_0/dynamic_pcell$4_0.DRN_NET_CD ota_cmfb_top_0.ota_cmfb_core_push_pull_output_stage_0/dynamic_pcell$4_0.SRC_NET_IJ_GATE_DI ota_cmfb_top_0.dynamic_pcell$5_0.DRN_NET_BD vdd_1v2.t0 sg13_lv_pmos ad=0.85p pd=5.68u as=0.475p ps=2.88u w=2.5u l=3u
X360 vss_1v2.t87 vss_1v2.t88 vss_1v2.t87 vss_1v2.t80 sg13_lv_nmos ad=62.5f pd=0.74u as=0 ps=0 w=0.25u l=0.5u
X361 ota_cmfb_top_0.dynamic_pcell$5_0.SRC_NET_AB analog_bus0 ota_cmfb_top_0.dynamic_pcell$5_0.DRN_NET_CA vdd_1v2.t0 sg13_lv_pmos ad=0.85p pd=5.68u as=0.475p ps=2.88u w=2.5u l=2u
X362 ota_cmfb_top_0.dynamic_pcell$5_0.DRN_NET_JL.t2 enable.t10 vdd_1v2.t0 vdd_1v2.t0 sg13_lv_pmos ad=0.1005p pd=1.34u as=0.1005p ps=1.34u w=0.15u l=0.13u
X363 vss_1v2.t189 vss_1v2.t188 ota_cmfb_top_0.ota_cmfb_core_push_pull_output_stage_1/dynamic_pcell$4_0.SRC_NET_ML vss_1v2.t101 sg13_lv_nmos ad=0.133p pd=1.08u as=0.133p ps=1.08u w=0.7u l=0.5u
X364 vdd_1v2.t0 vdd_1v2.t124 vdd_1v2.t123 vdd_1v2.t0 sg13_lv_pmos ad=0.2375p pd=1.63u as=0 ps=0 w=1.25u l=0.5u
X365 vdd_1v2.t188 vdd_1v2.t177 vdd_1v2.t190 vdd_1v2.t0 sg13_lv_pmos ad=95f pd=0.88u as=0 ps=0 w=0.5u l=0.5u
X366 vss_1v2.t185 vss_1v2.t186 vss_1v2.t187 vss_1v2.t97 sg13_lv_nmos ad=0.133p pd=1.08u as=0 ps=0 w=0.7u l=0.5u
X367 vdd_1v2.t193 vdd_1v2.t177 vdd_1v2.t195 vdd_1v2.t0 sg13_lv_pmos ad=95f pd=0.88u as=0 ps=0 w=0.5u l=0.5u
X368 vdd_1v2.t268 vdd_1v2.t258 vdd_1v2.t270 vdd_1v2.t0 sg13_lv_pmos ad=95f pd=0.88u as=0 ps=0 w=0.5u l=0.5u
X369 ota_cmfb_top_0.ota_cmfb_core_push_pull_output_stage_0/dynamic_pcell$4_0.DRN_NET_MENX ota_cmfb_top_0.ota_cmfb_core_push_pull_output_stage_0/dynamic_pcell$4_0.DRN_NET_OP_GATE_MP ota_cmfb_top_0.ota_cmfb_core_push_pull_output_stage_0/dynamic_pcell$4_0.SRC_NET_ML vss_1v2.t0 sg13_lv_nmos ad=0.133p pd=1.08u as=0.133p ps=1.08u w=0.7u l=3u
X370 vdd_1v2.t66 vdd_1v2.t64 vdd_1v2.t65 vdd_1v2.t0 sg13_lv_pmos ad=95f pd=0.88u as=0 ps=0 w=0.5u l=0.5u
X371 w_59515_33612# ota_cmfb_top_0.dynamic_pcell$5_0.DRN_NET_BD w_59515_33612# w_59515_33612# sg13_lv_pmos ad=7.31p pd=43.68u as=50.04169p ps=0.10913m w=21.5u l=3.5u
X372 vdd_1v2.t233 vdd_1v2.t231 vdd_1v2.t232 vdd_1v2.t0 sg13_lv_pmos ad=0.85p pd=5.68u as=0 ps=0 w=2.5u l=0.5u
X373 vdd_1v2.t63 vdd_1v2.t61 vdd_1v2.t62 vdd_1v2.t0 sg13_lv_pmos ad=0.2375p pd=1.63u as=0 ps=0 w=1.25u l=0.5u
X374 ota_cmfb_top_0.dynamic_pcell$5_0.DRN_NET_JL.t4 ota_cmfb_top_0.dynamic_pcell$5_0.Gate vss_1v2.t132 vss_1v2.t33 sg13_lv_nmos ad=62.5f pd=0.74u as=62.5f ps=0.74u w=0.25u l=10u
X375 vdd_1v2.t60 ota_cmfb_top_0.dynamic_pcell$5_0.H_DRN ota_cmfb_top_0.dynamic_pcell$5_0.SRC_NET_KL.t4 vdd_1v2.t0 sg13_lv_pmos ad=0.2375p pd=1.63u as=0.2375p ps=1.63u w=1.25u l=5u
X376 vdd_1v2.t166 vdd_1v2.t153 vdd_1v2.t154 vdd_1v2.t0 sg13_lv_pmos ad=95f pd=0.88u as=0 ps=0 w=0.5u l=0.5u
X377 ota_cmfb_top_0.dynamic_pcell$5_0.DRN_NET_BD analog_bus1 ota_cmfb_top_0.dynamic_pcell$5_0.SRC_NET_AB vdd_1v2.t0 sg13_lv_pmos ad=0.475p pd=2.88u as=0.85p ps=5.68u w=2.5u l=2u
X378 vss_1v2.t286 vss_1v2.t284 vss_1v2.t286 vss_1v2.t285 sg13_lv_nmos ad=0.17p pd=1.68u as=0 ps=0 w=0.5u l=0.5u
X379 vss_1v2.t34 ota_cmfb_top_0.dynamic_pcell$5_0.DRN_NET_E_GATE_CDEFGH.t11 ota_cmfb_top_0.dynamic_pcell$5_0.G_DRN.t1 vss_1v2.t33 sg13_lv_nmos ad=62.5f pd=0.74u as=62.5f ps=0.74u w=0.25u l=10u
X380 a_52197_34440# a_51933_34154# vss_1v2.t16 rhigh l=1u w=0.5u
X381 vdd_1v2.t393 ota_cmfb_top_0.dynamic_pcell$5_0.F_DRN ota_cmfb_top_0.ota_cmfb_core_push_pull_output_stage_0/dynamic_pcell$4_0.B_DRN vdd_1v2.t0 sg13_lv_pmos ad=0.475p pd=2.88u as=0.475p ps=2.88u w=2.5u l=3u
X382 vdd_1v2.t134 vdd_1v2.t135 vdd_1v2.t136 vdd_1v2.t0 sg13_lv_pmos ad=0.475p pd=2.88u as=0 ps=0 w=2.5u l=0.5u
X383 vss_1v2.t245 vss_1v2.t243 vss_1v2.t244 vss_1v2.t202 sg13_lv_nmos ad=0.238p pd=2.08u as=0 ps=0 w=0.7u l=0.5u
X384 vss_1v2.t12 vss_1v2.t12 vss_1v2.t12 vss_1v2.t276 sg13_lv_nmos ad=95f pd=0.88u as=0 ps=0 w=0.5u l=0.5u
X385 vss_1v2.t349 ota_cmfb_top_0.ota_cmfb_core_push_pull_output_stage_0/dynamic_pcell$4_0.Gate ota_cmfb_top_0.ota_cmfb_core_push_pull_output_stage_0/dynamic_pcell$4_0.Gate vss_1v2.t5 sg13_lv_nmos ad=0.133p pd=1.08u as=0.133p ps=1.08u w=0.7u l=3u
X386 vdd_1v2.t221 vdd_1v2.t219 vdd_1v2.t220 vdd_1v2.t0 sg13_lv_pmos ad=0.85p pd=5.68u as=0 ps=0 w=2.5u l=0.5u
X387 ota_cmfb_top_0.ota_cmfb_core_push_pull_output_stage_1/dynamic_pcell$4_0.SRC_NET_ML ota_cmfb_top_0.ota_cmfb_core_push_pull_output_stage_1/dynamic_pcell$4_0.Gate vss_1v2.t20 vss_1v2.t21 sg13_lv_nmos ad=0.133p pd=1.08u as=0.133p ps=1.08u w=0.7u l=3u
X388 vss_1v2.t145 ota_cmfb_top_0.dynamic_pcell$5_0.Gate ota_cmfb_top_0.dynamic_pcell$5_0.Gate vss_1v2.t318 sg13_lv_nmos ad=62.5f pd=0.74u as=62.5f ps=0.74u w=0.25u l=10u
X389 vdd_1v2.t2 ota_cmfb_top_0.dynamic_pcell$5_0.G_DRN ota_cmfb_top_0.ota_cmfb_core_push_pull_output_stage_1/dynamic_pcell$4_0.B_DRN vdd_1v2.t0 sg13_lv_pmos ad=0.85p pd=5.68u as=0.475p ps=2.88u w=2.5u l=3u
X390 s5_an[1] ota_cmfb_top_0.dynamic_pcell$5_0.DRN_NET_CA vdd_1v2.t27 vdd_1v2.t0 sg13_lv_pmos ad=95f pd=0.88u as=95f ps=0.88u w=0.5u l=0.5u
X391 ota_cmfb_top_0.dynamic_pcell$5_0.F_DRN.t1 ota_cmfb_top_0.dynamic_pcell$5_0.DRN_NET_E_GATE_CDEFGH.t10 vss_1v2.t34 vss_1v2.t318 sg13_lv_nmos ad=62.5f pd=0.74u as=62.5f ps=0.74u w=0.25u l=10u
X392 vdd_1v2.t283 vdd_1v2.t282 ota_cmfb_top_0.ota_cmfb_core_push_pull_output_stage_1/dynamic_pcell$4_0.DRN_NET_CD vdd_1v2.t0 sg13_lv_pmos ad=0.475p pd=2.88u as=0.475p ps=2.88u w=2.5u l=0.5u
X393 ota_cmfb_top_0.dynamic_pcell$5_0.DRN_NET_JL.t1 ota_cmfb_top_0.dynamic_pcell$5_0.L_GATE ota_cmfb_top_0.dynamic_pcell$5_0.SRC_NET_KL.t3 vdd_1v2.t0 sg13_lv_pmos ad=0.85p pd=5.68u as=0.475p ps=2.88u w=2.5u l=2u
X394 vdd_1v2.t0 vdd_1v2.t126 vdd_1v2.t0 vdd_1v2.t0 sg13_lv_pmos ad=0.2375p pd=1.63u as=0 ps=0 w=1.25u l=0.5u
X395 ota_cmfb_top_0.ota_cmfb_core_push_pull_output_stage_0/dynamic_pcell$4_0.SRC_NET_ML ota_cmfb_top_0.ota_cmfb_core_push_pull_output_stage_0/dynamic_pcell$4_0.Gate vss_1v2.t349 vss_1v2.t1 sg13_lv_nmos ad=0.133p pd=1.08u as=0.133p ps=1.08u w=0.7u l=3u
X396 ota_cmfb_top_0.ota_cmfb_core_push_pull_output_stage_1/dynamic_pcell$4_0.DRN_NET_CD ota_cmfb_top_0.ota_cmfb_core_push_pull_output_stage_1/dynamic_pcell$4_0.SRC_NET_IJ_GATE_DI ota_cmfb_top_0.dynamic_pcell$5_0.DRN_NET_CA vdd_1v2.t0 sg13_lv_pmos ad=0.85p pd=5.68u as=0.475p ps=2.88u w=2.5u l=3u
X397 ota_cmfb_top_0.dynamic_pcell$5_0.DRN_NET_CA analog_bus0 ota_cmfb_top_0.dynamic_pcell$5_0.SRC_NET_AB vdd_1v2.t0 sg13_lv_pmos ad=0.475p pd=2.88u as=0.475p ps=2.88u w=2.5u l=2u
X398 ota_cmfb_top_0.ota_cmfb_core_push_pull_output_stage_0/dynamic_pcell$4_0.SRC_NET_ML vss_1v2.t212 vss_1v2.t204 vss_1v2.t196 sg13_lv_nmos ad=0.133p pd=1.08u as=0.133p ps=1.08u w=0.7u l=0.5u
X399 ota_cmfb_top_0.ota_cmfb_core_push_pull_output_stage_1/dynamic_pcell$4_0.B_DRN ota_cmfb_top_0.dynamic_pcell$5_0.G_DRN vdd_1v2.t21 vdd_1v2.t0 sg13_lv_pmos ad=0.475p pd=2.88u as=0.85p ps=5.68u w=2.5u l=3u
X400 vdd_1v2.t60 ota_cmfb_top_0.dynamic_pcell$5_0.H_DRN ota_cmfb_top_0.dynamic_pcell$5_0.SRC_NET_KL.t5 vdd_1v2.t0 sg13_lv_pmos ad=0.2375p pd=1.63u as=0.2375p ps=1.63u w=1.25u l=5u
X401 w_52782_33612# ota_cmfb_top_0.dynamic_pcell$5_0.DRN_NET_CA w_52782_33612# w_52782_33612# sg13_lv_pmos ad=7.31p pd=43.68u as=50.04169p ps=0.10913m w=21.5u l=3.5u
X402 s5_an[1] a_52197_33631# vss_1v2.t32 rhigh l=1u w=0.5u
X403 vss_1v2.t34 ota_cmfb_top_0.dynamic_pcell$5_0.DRN_NET_E_GATE_CDEFGH.t0 ota_cmfb_top_0.dynamic_pcell$5_0.DRN_NET_E_GATE_CDEFGH.t1 vss_1v2.t33 sg13_lv_nmos ad=62.5f pd=0.74u as=62.5f ps=0.74u w=0.25u l=10u
X404 vdd_1v2.t158 vdd_1v2.t153 vdd_1v2.t176 vdd_1v2.t0 sg13_lv_pmos ad=95f pd=0.88u as=0 ps=0 w=0.5u l=0.5u
X405 vdd_1v2.t107 vdd_1v2.t105 vdd_1v2.t106 vdd_1v2.t0 sg13_lv_pmos ad=0.2375p pd=1.63u as=0 ps=0 w=1.25u l=0.5u
X406 vdd_1v2.t120 vdd_1v2.t118 vdd_1v2.t117 vdd_1v2.t0 sg13_lv_pmos ad=0.2375p pd=1.63u as=0 ps=0 w=1.25u l=0.5u
X407 ota_cmfb_top_0.dynamic_pcell$5_0.G_DRN.t9 ota_cmfb_top_0.dynamic_pcell$5_0.G_DRN vdd_1v2.t9 vdd_1v2.t0 sg13_lv_pmos ad=0.475p pd=2.88u as=0.475p ps=2.88u w=2.5u l=3u
X408 s5_an[2] ota_cmfb_top_0.dynamic_pcell$5_0.DRN_NET_BD vdd_1v2.t464 vdd_1v2.t0 sg13_lv_pmos ad=95f pd=0.88u as=95f ps=0.88u w=0.5u l=0.5u
X409 ota_cmfb_top_0.ota_cmfb_core_push_pull_output_stage_0/dynamic_pcell$4_0.DRN_NET_MENX vss_1v2.t227 vss_1v2.t228 vss_1v2.t5 sg13_lv_nmos ad=0.133p pd=1.08u as=0.133p ps=1.08u w=0.7u l=3u
X410 ota_cmfb_top_0.ota_cmfb_core_push_pull_output_stage_0/dynamic_pcell$4_0.DRN_NET_J_GATE_EJ ota_cmfb_top_0.ota_cmfb_core_push_pull_output_stage_0/dynamic_pcell$4_0.Gate vss_1v2.t349 vss_1v2.t3 sg13_lv_nmos ad=0.133p pd=1.08u as=0.133p ps=1.08u w=0.7u l=3u
X411 ota_cmfb_top_0.dynamic_pcell$5_0.SRC_NET_KL.t1 vdd_1v2.t144 vdd_1v2.t129 vdd_1v2.t0 sg13_lv_pmos ad=0.475p pd=2.88u as=0.475p ps=2.88u w=2.5u l=0.5u
X412 vdd_1v2.t242 vdd_1v2.t240 vdd_1v2.t239 vdd_1v2.t0 sg13_lv_pmos ad=0.475p pd=2.88u as=0 ps=0 w=2.5u l=0.5u
X413 vdd_1v2.t13 vdd_1v2.t301 vdd_1v2.t302 vdd_1v2.t0 sg13_lv_pmos ad=0.475p pd=2.88u as=0 ps=0 w=2.5u l=0.5u
X414 ota_cmfb_top_0.dynamic_pcell$5_0.DRN_NET_CA enable.t9 vdd_1v2.t400 vdd_1v2.t0 sg13_lv_pmos ad=0.1005p pd=1.34u as=0.1005p ps=1.34u w=0.15u l=0.13u
X415 ota_cmfb_top_0.ota_cmfb_core_push_pull_output_stage_0/dynamic_pcell$4_0.DRN_NET_CD vdd_1v2.t394 vdd_1v2.t389 vdd_1v2.t0 sg13_lv_pmos ad=0.475p pd=2.88u as=0.475p ps=2.88u w=2.5u l=0.5u
X416 vss_1v2.t192 vss_1v2.t190 vss_1v2.t191 vss_1v2.t149 sg13_lv_nmos ad=0.238p pd=2.08u as=0 ps=0 w=0.7u l=0.5u
X417 vdd_1v2.t307 vdd_1v2.t306 ota_cmfb_top_0.dynamic_pcell$5_0.DRN_NET_CA vdd_1v2.t0 sg13_lv_pmos ad=0.475p pd=2.88u as=0.475p ps=2.88u w=2.5u l=0.5u
X418 a_58402_33917# a_58402_33631# vss_1v2.t43 rhigh l=1u w=0.5u
X419 ota_cmfb_top_0.ota_cmfb_core_push_pull_output_stage_0/dynamic_pcell$4_0.B_DRN ota_cmfb_top_0.dynamic_pcell$5_0.F_DRN vdd_1v2.t451 vdd_1v2.t0 sg13_lv_pmos ad=0.475p pd=2.88u as=0.85p ps=5.68u w=2.5u l=3u
X420 vdd_1v2.t7 ota_cmfb_top_0.dynamic_pcell$5_0.G_DRN ota_cmfb_top_0.ota_cmfb_core_push_pull_output_stage_1/dynamic_pcell$4_0.DRN_NET_HI vdd_1v2.t0 sg13_lv_pmos ad=0.85p pd=5.68u as=0.475p ps=2.88u w=2.5u l=3u
X421 ota_cmfb_top_0.dynamic_pcell$5_0.H_DRN.t2 ota_cmfb_top_0.dynamic_pcell$5_0.DRN_NET_E_GATE_CDEFGH.t9 vss_1v2.t34 vss_1v2.t318 sg13_lv_nmos ad=62.5f pd=0.74u as=62.5f ps=0.74u w=0.25u l=10u
X422 vdd_1v2.t326 vdd_1v2.t324 vdd_1v2.t325 vdd_1v2.t0 sg13_lv_pmos ad=0.85p pd=5.68u as=0 ps=0 w=2.5u l=0.5u
X423 vss_1v2.t20 ota_cmfb_top_0.ota_cmfb_core_push_pull_output_stage_1/dynamic_pcell$4_0.Gate ota_cmfb_top_0.ota_cmfb_core_push_pull_output_stage_1/dynamic_pcell$4_0.DRN_NET_J_GATE_EJ vss_1v2.t27 sg13_lv_nmos ad=0.133p pd=1.08u as=0.133p ps=1.08u w=0.7u l=3u
X424 a_49340_27979# a_49076_27693# vss_1v2.t323 rhigh l=1u w=0.5u
X425 vss_1v2.t20 ota_cmfb_top_0.ota_cmfb_core_push_pull_output_stage_1/dynamic_pcell$4_0.Gate ota_cmfb_top_0.ota_cmfb_core_push_pull_output_stage_1/dynamic_pcell$4_0.DRN_NET_J_GATE_EJ vss_1v2.t24 sg13_lv_nmos ad=0.133p pd=1.08u as=0.133p ps=1.08u w=0.7u l=3u
X426 vdd_1v2.t292 vdd_1v2.t297 ota_cmfb_top_0.ota_cmfb_core_push_pull_output_stage_1/dynamic_pcell$4_0.SRC_NET_IJ_GATE_DI vdd_1v2.t0 sg13_lv_pmos ad=0.475p pd=2.88u as=0.475p ps=2.88u w=2.5u l=0.5u
X427 ota_cmfb_top_0.dynamic_pcell$5_0.G_DRN.t13 enable.t8 vdd_1v2.t405 vdd_1v2.t0 sg13_lv_pmos ad=0.1005p pd=1.34u as=0.1005p ps=1.34u w=0.15u l=0.13u
X428 vss_1v2.t349 ota_cmfb_top_0.ota_cmfb_core_push_pull_output_stage_0/dynamic_pcell$4_0.Gate ota_cmfb_top_0.ota_cmfb_core_push_pull_output_stage_0/dynamic_pcell$4_0.DRN_NET_J_GATE_EJ vss_1v2.t2 sg13_lv_nmos ad=0.133p pd=1.08u as=0.133p ps=1.08u w=0.7u l=3u
X429 vdd_1v2.t230 vdd_1v2.t228 vdd_1v2.t227 vdd_1v2.t0 sg13_lv_pmos ad=0.475p pd=2.88u as=0 ps=0 w=2.5u l=0.5u
X430 ota_cmfb_top_0.dynamic_pcell$5_0.F_DRN.t12 ota_cmfb_top_0.dynamic_pcell$5_0.F_DRN vdd_1v2.t447 vdd_1v2.t0 sg13_lv_pmos ad=0.475p pd=2.88u as=0.475p ps=2.88u w=2.5u l=3u
X431 vss_1v2.t58 enable.t1 ota_cmfb_top_0.ota_cmfb_core_push_pull_output_stage_1/EN_INV_0/sg13cmos5l_inv_4_0.Y vss_1v2.t59 sg13_lv_nmos ad=0.1406p pd=1.12u as=0.1406p ps=1.12u w=0.74u l=0.13u
X432 vss_1v2.t34 ota_cmfb_top_0.dynamic_pcell$5_0.DRN_NET_E_GATE_CDEFGH.t8 ota_cmfb_top_0.dynamic_pcell$5_0.H_DRN.t3 vss_1v2.t33 sg13_lv_nmos ad=62.5f pd=0.74u as=62.5f ps=0.74u w=0.25u l=10u
X433 vss_1v2.t12 vss_1v2.t12 vss_1v2.t12 vss_1v2.t248 sg13_lv_nmos ad=0.17p pd=1.68u as=0 ps=0 w=0.5u l=0.5u
X434 vss_1v2.t207 vss_1v2.t214 ota_cmfb_top_0.ota_cmfb_core_push_pull_output_stage_0/dynamic_pcell$4_0.SRC_NET_ML vss_1v2.t210 sg13_lv_nmos ad=0.133p pd=1.08u as=0.133p ps=1.08u w=0.7u l=0.5u
X435 ota_cmfb_top_0.ota_cmfb_core_push_pull_output_stage_0/dynamic_pcell$4_0.DRN_NET_CD ota_cmfb_top_0.dynamic_pcell$5_0.F_DRN vdd_1v2.t433 vdd_1v2.t0 sg13_lv_pmos ad=0.475p pd=2.88u as=0.475p ps=2.88u w=2.5u l=3u
X436 ota_cmfb_top_0.ota_cmfb_core_push_pull_output_stage_0/dynamic_pcell$4_0.DRN_NET_OP_GATE_MP ota_cmfb_top_0.ota_cmfb_core_push_pull_output_stage_0/dynamic_pcell$4_0.B_DRN ota_cmfb_top_0.ota_cmfb_core_push_pull_output_stage_0/dynamic_pcell$4_0.B_DRN vss_1v2.t5 sg13_lv_nmos ad=0.133p pd=1.08u as=0.133p ps=1.08u w=0.7u l=3u
X437 ota_cmfb_top_0.dynamic_pcell$5_0.DRN_NET_CA ota_cmfb_top_0.ota_cmfb_core_push_pull_output_stage_1/dynamic_pcell$4_0.SRC_NET_IJ_GATE_DI ota_cmfb_top_0.ota_cmfb_core_push_pull_output_stage_1/dynamic_pcell$4_0.DRN_NET_CD vdd_1v2.t0 sg13_lv_pmos ad=0.475p pd=2.88u as=0.475p ps=2.88u w=2.5u l=3u
X438 vss_1v2.t349 ota_cmfb_top_0.ota_cmfb_core_push_pull_output_stage_0/dynamic_pcell$4_0.Gate ota_cmfb_top_0.ota_cmfb_core_push_pull_output_stage_0/dynamic_pcell$4_0.DRN_NET_J_GATE_EJ vss_1v2.t0 sg13_lv_nmos ad=0.133p pd=1.08u as=0.133p ps=1.08u w=0.7u l=3u
X439 ota_cmfb_top_0.ota_cmfb_core_push_pull_output_stage_1/dynamic_pcell$4_0.SRC_NET_IJ_GATE_DI ota_cmfb_top_0.ota_cmfb_core_push_pull_output_stage_1/dynamic_pcell$4_0.DRN_NET_J_GATE_EJ ota_cmfb_top_0.ota_cmfb_core_push_pull_output_stage_1/dynamic_pcell$4_0.DRN_NET_J_GATE_EJ vdd_1v2.t0 sg13_lv_pmos ad=0.475p pd=2.88u as=0.475p ps=2.88u w=2.5u l=3u
X440 ota_cmfb_top_0.dynamic_pcell$5_0.DRN_NET_BD ota_cmfb_top_0.ota_cmfb_core_push_pull_output_stage_0/dynamic_pcell$4_0.SRC_NET_IJ_GATE_DI ota_cmfb_top_0.ota_cmfb_core_push_pull_output_stage_0/dynamic_pcell$4_0.DRN_NET_CD vdd_1v2.t0 sg13_lv_pmos ad=0.475p pd=2.88u as=0.475p ps=2.88u w=2.5u l=3u
X441 vdd_1v2.t45 vdd_1v2.t43 vdd_1v2.t42 vdd_1v2.t0 sg13_lv_pmos ad=0.2375p pd=1.63u as=0 ps=0 w=1.25u l=0.5u
X442 vdd_1v2.t18 vdd_1v2.t280 vdd_1v2.t281 vdd_1v2.t0 sg13_lv_pmos ad=0.475p pd=2.88u as=0 ps=0 w=2.5u l=0.5u
X443 ota_cmfb_top_0.ota_cmfb_core_push_pull_output_stage_0/dynamic_pcell$4_0.DRN_NET_CD ota_cmfb_top_0.ota_cmfb_core_push_pull_output_stage_0/dynamic_pcell$4_0.SRC_NET_IJ_GATE_DI ota_cmfb_top_0.dynamic_pcell$5_0.DRN_NET_BD vdd_1v2.t0 sg13_lv_pmos ad=0.475p pd=2.88u as=0.475p ps=2.88u w=2.5u l=3u
X444 ota_cmfb_top_0.dynamic_pcell$5_0.DRN_NET_E_GATE_CDEFGH.t3 ota_cmfb_top_0.dynamic_pcell$5_0.DRN_NET_E_GATE_CDEFGH.t2 vss_1v2.t34 vss_1v2.t318 sg13_lv_nmos ad=62.5f pd=0.74u as=62.5f ps=0.74u w=0.25u l=10u
X445 a_49076_27418# a_49340_27132# vss_1v2.t6 rhigh l=1u w=0.5u
X446 ota_cmfb_top_0.ota_cmfb_core_push_pull_output_stage_1/dynamic_pcell$4_0.DRN_NET_J_GATE_EJ ota_cmfb_top_0.ota_cmfb_core_push_pull_output_stage_1/dynamic_pcell$4_0.Gate vss_1v2.t20 vss_1v2.t19 sg13_lv_nmos ad=0.133p pd=1.08u as=0.133p ps=1.08u w=0.7u l=3u
X447 ota_cmfb_top_0.dynamic_pcell$5_0.SRC_NET_AB ota_cmfb_top_0.dynamic_pcell$5_0.DRN_NET_JL vdd_1v2.t236 vdd_1v2.t0 sg13_lv_pmos ad=0.475p pd=2.88u as=0.475p ps=2.88u w=2.5u l=10u
X448 vss_1v2.t98 vss_1v2.t100 ota_cmfb_top_0.ota_cmfb_core_push_pull_output_stage_1/dynamic_pcell$4_0.DRN_NET_OP_GATE_MP vss_1v2.t101 sg13_lv_nmos ad=0.133p pd=1.08u as=0.133p ps=1.08u w=0.7u l=0.5u
X449 vdd_1v2.t340 ota_cmfb_top_0.dynamic_pcell$5_0.F_DRN ota_cmfb_top_0.dynamic_pcell$5_0.F_DRN.t7 vdd_1v2.t0 sg13_lv_pmos ad=0.475p pd=2.88u as=0.475p ps=2.88u w=2.5u l=3u
X450 ota_cmfb_top_0.dynamic_pcell$5_0.DRN_NET_BD ota_cmfb_top_0.ota_cmfb_core_push_pull_output_stage_0/dynamic_pcell$4_0.DRN_NET_J_GATE_EJ ota_cmfb_top_0.ota_cmfb_core_push_pull_output_stage_0/dynamic_pcell$4_0.DRN_NET_MENX vdd_1v2.t0 sg13_lv_pmos ad=0.475p pd=2.88u as=0.85p ps=5.68u w=2.5u l=3u
X451 vdd_1v2.t449 ota_cmfb_top_0.dynamic_pcell$5_0.F_DRN ota_cmfb_top_0.dynamic_pcell$5_0.F_DRN.t12 vdd_1v2.t0 sg13_lv_pmos ad=0.85p pd=5.68u as=0.475p ps=2.88u w=2.5u l=3u
X452 vdd_1v2.t5 ota_cmfb_top_0.dynamic_pcell$5_0.G_DRN ota_cmfb_top_0.ota_cmfb_core_push_pull_output_stage_1/dynamic_pcell$4_0.DRN_NET_CD vdd_1v2.t0 sg13_lv_pmos ad=0.475p pd=2.88u as=0.475p ps=2.88u w=2.5u l=3u
X453 ota_cmfb_top_0.dynamic_pcell$5_0.DRN_NET_JL.t0 ota_cmfb_top_0.dynamic_pcell$5_0.L_GATE ota_cmfb_top_0.dynamic_pcell$5_0.SRC_NET_KL.t2 vdd_1v2.t0 sg13_lv_pmos ad=0.475p pd=2.88u as=0.85p ps=5.68u w=2.5u l=2u
X454 vdd_1v2.t0 enable.t11 ota_cmfb_top_0.dynamic_pcell$5_0.H_DRN.t6 vdd_1v2.t0 sg13_lv_pmos ad=0.1005p pd=1.34u as=0.1005p ps=1.34u w=0.15u l=0.13u
X455 s5_an[2] ota_cmfb_top_0.dynamic_pcell$5_0.DRN_NET_BD vdd_1v2.t462 vdd_1v2.t0 sg13_lv_pmos ad=95f pd=0.88u as=95f ps=0.88u w=0.5u l=0.5u
X456 ota_cmfb_top_0.ota_cmfb_core_push_pull_output_stage_1/dynamic_pcell$4_0.DRN_NET_J_GATE_EJ ota_cmfb_top_0.ota_cmfb_core_push_pull_output_stage_1/dynamic_pcell$4_0.Gate vss_1v2.t20 vss_1v2.t21 sg13_lv_nmos ad=0.133p pd=1.08u as=0.133p ps=1.08u w=0.7u l=3u
X457 vss_1v2.t34 ota_cmfb_top_0.dynamic_pcell$5_0.DRN_NET_E_GATE_CDEFGH.t7 ota_cmfb_top_0.dynamic_pcell$5_0.F_DRN.t2 vss_1v2.t33 sg13_lv_nmos ad=62.5f pd=0.74u as=62.5f ps=0.74u w=0.25u l=10u
X458 ota_cmfb_top_0.ota_cmfb_core_push_pull_output_stage_0/dynamic_pcell$4_0.SRC_NET_IJ_GATE_DI ota_cmfb_top_0.ota_cmfb_core_push_pull_output_stage_0/dynamic_pcell$4_0.SRC_NET_IJ_GATE_DI ota_cmfb_top_0.ota_cmfb_core_push_pull_output_stage_0/dynamic_pcell$4_0.DRN_NET_HI vdd_1v2.t0 sg13_lv_pmos ad=0.85p pd=5.68u as=0.475p ps=2.88u w=2.5u l=3u
X459 vdd_1v2.t86 vdd_1v2.t84 vdd_1v2.t83 vdd_1v2.t0 sg13_lv_pmos ad=0.2375p pd=1.63u as=0 ps=0 w=1.25u l=0.5u
X460 vdd_1v2.t215 vdd_1v2.t213 vdd_1v2.t214 vdd_1v2.t0 sg13_lv_pmos ad=0.475p pd=2.88u as=0 ps=0 w=2.5u l=0.5u
X461 ota_cmfb_top_0.ota_cmfb_core_push_pull_output_stage_0/EN_INV_0/sg13cmos5l_inv_4_0.Y enable.t0 vss_1v2.t56 vss_1v2.t55 sg13_lv_nmos ad=0.1406p pd=1.12u as=0.2516p ps=2.16u w=0.74u l=0.13u
X462 vss_1v2.t145 vss_1v2.t144 vss_1v2.t145 vss_1v2.t73 sg13_lv_nmos ad=62.5f pd=0.74u as=0 ps=0 w=0.25u l=0.5u
X463 ota_cmfb_top_0.dynamic_pcell$5_0.SRC_NET_AB ota_cmfb_top_0.dynamic_pcell$5_0.DRN_NET_JL vdd_1v2.t224 vdd_1v2.t0 sg13_lv_pmos ad=0.475p pd=2.88u as=0.475p ps=2.88u w=2.5u l=10u
X464 vdd_1v2.t439 ota_cmfb_top_0.dynamic_pcell$5_0.F_DRN ota_cmfb_top_0.dynamic_pcell$5_0.F_DRN.t5 vdd_1v2.t0 sg13_lv_pmos ad=0.475p pd=2.88u as=0.475p ps=2.88u w=2.5u l=3u
X465 ota_cmfb_top_0.ota_cmfb_core_push_pull_output_stage_0/dynamic_pcell$4_0.SRC_NET_IJ_GATE_DI ota_cmfb_top_0.ota_cmfb_core_push_pull_output_stage_0/dynamic_pcell$4_0.DRN_NET_J_GATE_EJ ota_cmfb_top_0.ota_cmfb_core_push_pull_output_stage_0/dynamic_pcell$4_0.DRN_NET_J_GATE_EJ vdd_1v2.t0 sg13_lv_pmos ad=0.475p pd=2.88u as=0.475p ps=2.88u w=2.5u l=3u
X466 vdd_1v2.t415 enable.t1 ota_cmfb_top_0.ota_cmfb_core_push_pull_output_stage_1/EN_INV_0/sg13cmos5l_inv_4_0.Y vdd_1v2.t0 sg13_lv_pmos ad=0.2128p pd=1.5u as=0.2128p ps=1.5u w=1.12u l=0.13u
X467 vss_1v2.t78 vss_1v2.t77 ota_cmfb_top_0.dynamic_pcell$5_0.F_DRN.t1 vss_1v2.t73 sg13_lv_nmos ad=62.5f pd=0.74u as=62.5f ps=0.74u w=0.25u l=0.5u
X468 vdd_1v2.t353 vdd_1v2.t351 vdd_1v2.t349 vdd_1v2.t0 sg13_lv_pmos ad=0.475p pd=2.88u as=0 ps=0 w=2.5u l=0.5u
X469 vss_1v2.t218 vss_1v2.t216 vss_1v2.t217 vss_1v2.t202 sg13_lv_nmos ad=0.238p pd=2.08u as=0 ps=0 w=0.7u l=0.5u
X470 vdd_1v2.t433 ota_cmfb_top_0.dynamic_pcell$5_0.F_DRN ota_cmfb_top_0.ota_cmfb_core_push_pull_output_stage_0/dynamic_pcell$4_0.DRN_NET_CD vdd_1v2.t0 sg13_lv_pmos ad=0.475p pd=2.88u as=0.475p ps=2.88u w=2.5u l=3u
X471 vdd_1v2.t57 vdd_1v2.t55 vdd_1v2.t54 vdd_1v2.t0 sg13_lv_pmos ad=0.2375p pd=1.63u as=0 ps=0 w=1.25u l=0.5u
X472 vdd_1v2.t184 vdd_1v2.t177 vdd_1v2.t186 vdd_1v2.t0 sg13_lv_pmos ad=95f pd=0.88u as=0 ps=0 w=0.5u l=0.5u
X473 ota_cmfb_top_0.ota_cmfb_core_push_pull_output_stage_0/dynamic_pcell$4_0.SRC_NET_ML vss_1v2.t257 vss_1v2.t245 vss_1v2.t196 sg13_lv_nmos ad=0.133p pd=1.08u as=0.133p ps=1.08u w=0.7u l=0.5u
X474 ota_cmfb_top_0.dynamic_pcell$5_0.G_DRN.t2 ota_cmfb_top_0.dynamic_pcell$5_0.DRN_NET_E_GATE_CDEFGH.t6 vss_1v2.t34 vss_1v2.t318 sg13_lv_nmos ad=62.5f pd=0.74u as=62.5f ps=0.74u w=0.25u l=10u
X475 ota_cmfb_top_0.dynamic_pcell$5_0.G_DRN.t6 ota_cmfb_top_0.dynamic_pcell$5_0.G_DRN vdd_1v2.t11 vdd_1v2.t0 sg13_lv_pmos ad=0.475p pd=2.88u as=0.475p ps=2.88u w=2.5u l=3u
X476 vdd_1v2.t277 vdd_1v2.t275 vdd_1v2.t276 vdd_1v2.t0 sg13_lv_pmos ad=0.85p pd=5.68u as=0 ps=0 w=2.5u l=0.5u
X477 vss_1v2.t175 vss_1v2.t174 ota_cmfb_top_0.ota_cmfb_core_push_pull_output_stage_1/dynamic_pcell$4_0.DRN_NET_MENX vss_1v2.t101 sg13_lv_nmos ad=0.133p pd=1.08u as=0.133p ps=1.08u w=0.7u l=0.5u
X478 ota_cmfb_top_0.ota_cmfb_core_push_pull_output_stage_0/dynamic_pcell$4_0.SRC_NET_IJ_GATE_DI ota_cmfb_top_0.ota_cmfb_core_push_pull_output_stage_0/dynamic_pcell$4_0.SRC_NET_IJ_GATE_DI ota_cmfb_top_0.ota_cmfb_core_push_pull_output_stage_0/dynamic_pcell$4_0.DRN_NET_HI vdd_1v2.t0 sg13_lv_pmos ad=0.475p pd=2.88u as=0.475p ps=2.88u w=2.5u l=3u
X479 ota_cmfb_top_0.dynamic_pcell$5_0.G_DRN.t11 ota_cmfb_top_0.dynamic_pcell$5_0.G_DRN vdd_1v2.t14 vdd_1v2.t0 sg13_lv_pmos ad=0.475p pd=2.88u as=0.475p ps=2.88u w=2.5u l=3u
X480 vdd_1v2.t259 vdd_1v2.t258 vdd_1v2.t262 vdd_1v2.t0 sg13_lv_pmos ad=95f pd=0.88u as=0 ps=0 w=0.5u l=0.5u
X481 vdd_1v2.t147 vdd_1v2.t146 ota_cmfb_top_0.dynamic_pcell$5_0.SRC_NET_AB vdd_1v2.t0 sg13_lv_pmos ad=0.475p pd=2.88u as=0.475p ps=2.88u w=2.5u l=0.5u
X482 vdd_1v2.t214 ota_cmfb_top_0.dynamic_pcell$5_0.DRN_NET_JL ota_cmfb_top_0.dynamic_pcell$5_0.SRC_NET_AB vdd_1v2.t0 sg13_lv_pmos ad=0.475p pd=2.88u as=0.475p ps=2.88u w=2.5u l=10u
X483 vss_1v2.t47 enable.t3 ota_cmfb_top_0.EN_INV_1/sg13cmos5l_inv_4_0.Y vss_1v2.t45 sg13_lv_nmos ad=0.1406p pd=1.12u as=0.1406p ps=1.12u w=0.74u l=0.13u
X484 vdd_1v2.t203 vdd_1v2.t201 vdd_1v2.t202 vdd_1v2.t0 sg13_lv_pmos ad=0.475p pd=2.88u as=0 ps=0 w=2.5u l=0.5u
X485 vdd_1v2.t245 vdd_1v2.t64 vdd_1v2.t244 vdd_1v2.t0 sg13_lv_pmos ad=0.17p pd=1.68u as=0 ps=0 w=0.5u l=0.5u
X486 vdd_1v2.t132 vdd_1v2.t131 ota_cmfb_top_0.dynamic_pcell$5_0.Gate vdd_1v2.t0 sg13_lv_pmos ad=0.475p pd=2.88u as=0.475p ps=2.88u w=2.5u l=0.5u
X487 ota_cmfb_top_0.EN_INV_0/sg13cmos5l_inv_4_0.Y enable.t4 vss_1v2.t46 vss_1v2.t45 sg13_lv_nmos ad=0.1406p pd=1.12u as=0.1406p ps=1.12u w=0.74u l=0.13u
X488 vdd_1v2.t393 vdd_1v2.t391 vdd_1v2.t392 vdd_1v2.t0 sg13_lv_pmos ad=0.475p pd=2.88u as=0 ps=0 w=2.5u l=0.5u
X489 vdd_1v2.t97 vdd_1v2.t98 vdd_1v2.t99 vdd_1v2.t0 sg13_lv_pmos ad=0.2375p pd=1.63u as=0 ps=0 w=1.25u l=0.5u
X490 vss_1v2.t20 ota_cmfb_top_0.ota_cmfb_core_push_pull_output_stage_1/dynamic_pcell$4_0.Gate ota_cmfb_top_0.ota_cmfb_core_push_pull_output_stage_1/dynamic_pcell$4_0.SRC_NET_ML vss_1v2.t22 sg13_lv_nmos ad=0.133p pd=1.08u as=0.133p ps=1.08u w=0.7u l=3u
X491 vdd_1v2.t378 ota_cmfb_top_0.dynamic_pcell$5_0.F_DRN ota_cmfb_top_0.ota_cmfb_core_push_pull_output_stage_0/dynamic_pcell$4_0.DRN_NET_HI vdd_1v2.t0 sg13_lv_pmos ad=0.475p pd=2.88u as=0.475p ps=2.88u w=2.5u l=3u
X492 ota_cmfb_top_0.ota_cmfb_core_push_pull_output_stage_1/dynamic_pcell$4_0.DRN_NET_J_GATE_EJ ota_cmfb_top_0.ota_cmfb_core_push_pull_output_stage_1/dynamic_pcell$4_0.DRN_NET_J_GATE_EJ ota_cmfb_top_0.ota_cmfb_core_push_pull_output_stage_1/dynamic_pcell$4_0.SRC_NET_IJ_GATE_DI vdd_1v2.t0 sg13_lv_pmos ad=0.475p pd=2.88u as=0.475p ps=2.88u w=2.5u l=3u
X493 s5_an[1] ota_cmfb_top_0.dynamic_pcell$5_0.DRN_NET_CA vdd_1v2.t31 vdd_1v2.t0 sg13_lv_pmos ad=95f pd=0.88u as=95f ps=0.88u w=0.5u l=0.5u
X494 ota_cmfb_top_0.ota_cmfb_core_push_pull_output_stage_0/dynamic_pcell$4_0.DRN_NET_MENX vdd_1v2.t362 vdd_1v2.t337 vdd_1v2.t0 sg13_lv_pmos ad=0.475p pd=2.88u as=0.475p ps=2.88u w=2.5u l=0.5u
X495 s5_an[2] ota_cmfb_top_0.dynamic_pcell$5_0.DRN_NET_BD vdd_1v2.t466 vdd_1v2.t0 sg13_lv_pmos ad=95f pd=0.88u as=95f ps=0.88u w=0.5u l=0.5u
X496 ota_cmfb_top_0.ota_cmfb_core_push_pull_output_stage_0/dynamic_pcell$4_0.DRN_NET_OP_GATE_MP ota_cmfb_top_0.ota_cmfb_core_push_pull_output_stage_0/dynamic_pcell$4_0.B_DRN ota_cmfb_top_0.ota_cmfb_core_push_pull_output_stage_0/dynamic_pcell$4_0.B_DRN vss_1v2.t1 sg13_lv_nmos ad=0.133p pd=1.08u as=0.133p ps=1.08u w=0.7u l=3u
X497 ota_cmfb_top_0.dynamic_pcell$5_0.F_DRN.t0 vdd_1v2.t379 vdd_1v2.t369 vdd_1v2.t0 sg13_lv_pmos ad=0.475p pd=2.88u as=0.475p ps=2.88u w=2.5u l=0.5u
X498 ota_cmfb_top_0.dynamic_pcell$5_0.Gate ota_cmfb_top_0.dynamic_pcell$5_0.Gate vss_1v2.t71 vss_1v2.t33 sg13_lv_nmos ad=62.5f pd=0.74u as=62.5f ps=0.74u w=0.25u l=10u
X499 ota_cmfb_top_0.dynamic_pcell$5_0.F_DRN.t7 ota_cmfb_top_0.dynamic_pcell$5_0.F_DRN vdd_1v2.t439 vdd_1v2.t0 sg13_lv_pmos ad=0.475p pd=2.88u as=0.475p ps=2.88u w=2.5u l=3u
X500 vdd_1v2.t202 ota_cmfb_top_0.dynamic_pcell$5_0.DRN_NET_JL ota_cmfb_top_0.dynamic_pcell$5_0.SRC_NET_AB vdd_1v2.t0 sg13_lv_pmos ad=0.475p pd=2.88u as=0.475p ps=2.88u w=2.5u l=10u
X501 vdd_1v2.t296 vdd_1v2.t294 vdd_1v2.t295 vdd_1v2.t0 sg13_lv_pmos ad=0.85p pd=5.68u as=0 ps=0 w=2.5u l=0.5u
X502 ota_cmfb_top_0.ota_cmfb_core_push_pull_output_stage_1/dynamic_pcell$4_0.DRN_NET_CD ota_cmfb_top_0.ota_cmfb_core_push_pull_output_stage_1/dynamic_pcell$4_0.SRC_NET_IJ_GATE_DI ota_cmfb_top_0.dynamic_pcell$5_0.DRN_NET_CA vdd_1v2.t0 sg13_lv_pmos ad=0.475p pd=2.88u as=0.475p ps=2.88u w=2.5u l=3u
X503 vss_1v2.t110 vss_1v2.t111 ota_cmfb_top_0.dynamic_pcell$5_0.H_DRN.t2 vss_1v2.t73 sg13_lv_nmos ad=62.5f pd=0.74u as=62.5f ps=0.74u w=0.25u l=0.5u
X504 vdd_1v2.t310 vdd_1v2.t308 vdd_1v2.t309 vdd_1v2.t0 sg13_lv_pmos ad=0.85p pd=5.68u as=0 ps=0 w=2.5u l=0.5u
X505 vss_1v2.t20 ota_cmfb_top_0.ota_cmfb_core_push_pull_output_stage_1/dynamic_pcell$4_0.Gate ota_cmfb_top_0.ota_cmfb_core_push_pull_output_stage_1/dynamic_pcell$4_0.SRC_NET_ML vss_1v2.t24 sg13_lv_nmos ad=0.133p pd=1.08u as=0.133p ps=1.08u w=0.7u l=3u
X506 vss_1v2.t226 vss_1v2.t224 vss_1v2.t197 vss_1v2.t202 sg13_lv_nmos ad=0.238p pd=2.08u as=0 ps=0 w=0.7u l=0.5u
X507 vss_1v2.t349 ota_cmfb_top_0.ota_cmfb_core_push_pull_output_stage_0/dynamic_pcell$4_0.Gate ota_cmfb_top_0.ota_cmfb_core_push_pull_output_stage_0/dynamic_pcell$4_0.SRC_NET_ML vss_1v2.t2 sg13_lv_nmos ad=0.133p pd=1.08u as=0.133p ps=1.08u w=0.7u l=3u
X508 ota_cmfb_top_0.ota_cmfb_core_push_pull_output_stage_0/EN_INV_0/sg13cmos5l_inv_4_0.Y enable.t0 vdd_1v2.t418 vdd_1v2.t0 sg13_lv_pmos ad=0.2128p pd=1.5u as=0.3808p ps=2.92u w=1.12u l=0.13u
X509 vdd_1v2.t359 vdd_1v2.t357 vdd_1v2.t356 vdd_1v2.t0 sg13_lv_pmos ad=0.475p pd=2.88u as=0 ps=0 w=2.5u l=0.5u
X510 vdd_1v2.t19 ota_cmfb_top_0.dynamic_pcell$5_0.G_DRN ota_cmfb_top_0.ota_cmfb_core_push_pull_output_stage_1/dynamic_pcell$4_0.DRN_NET_CD vdd_1v2.t0 sg13_lv_pmos ad=0.475p pd=2.88u as=0.475p ps=2.88u w=2.5u l=3u
X511 vdd_1v2.t0 vdd_1v2.t87 vdd_1v2.t86 vdd_1v2.t0 sg13_lv_pmos ad=0.2375p pd=1.63u as=0 ps=0 w=1.25u l=0.5u
X512 vdd_1v2.t212 vdd_1v2.t210 vdd_1v2.t208 vdd_1v2.t0 sg13_lv_pmos ad=0.475p pd=2.88u as=0 ps=0 w=2.5u l=0.5u
X513 vss_1v2.t185 vss_1v2.t184 ota_cmfb_top_0.ota_cmfb_core_push_pull_output_stage_1/dynamic_pcell$4_0.DRN_NET_OP_GATE_MP vss_1v2.t101 sg13_lv_nmos ad=0.133p pd=1.08u as=0.133p ps=1.08u w=0.7u l=0.5u
X514 ota_cmfb_top_0.ota_cmfb_core_push_pull_output_stage_0/dynamic_pcell$4_0.DRN_NET_OP_GATE_MP ota_cmfb_top_0.ota_cmfb_core_push_pull_output_stage_0/dynamic_pcell$4_0.DRN_NET_OP_GATE_MP ota_cmfb_top_0.ota_cmfb_core_push_pull_output_stage_0/dynamic_pcell$4_0.Gate vss_1v2.t3 sg13_lv_nmos ad=0.133p pd=1.08u as=0.133p ps=1.08u w=0.7u l=3u
X515 ota_cmfb_top_0.ota_cmfb_core_push_pull_output_stage_0/dynamic_pcell$4_0.DRN_NET_J_GATE_EJ ota_cmfb_top_0.ota_cmfb_core_push_pull_output_stage_0/dynamic_pcell$4_0.DRN_NET_J_GATE_EJ ota_cmfb_top_0.ota_cmfb_core_push_pull_output_stage_0/dynamic_pcell$4_0.SRC_NET_IJ_GATE_DI vdd_1v2.t0 sg13_lv_pmos ad=0.475p pd=2.88u as=0.475p ps=2.88u w=2.5u l=3u
X516 ota_cmfb_top_0.dynamic_pcell$5_0.DRN_NET_BD analog_bus1 ota_cmfb_top_0.dynamic_pcell$5_0.SRC_NET_AB vdd_1v2.t0 sg13_lv_pmos ad=0.475p pd=2.88u as=0.475p ps=2.88u w=2.5u l=2u
X517 ota_cmfb_top_0.dynamic_pcell$5_0.SRC_NET_AB analog_bus1 ota_cmfb_top_0.dynamic_pcell$5_0.DRN_NET_BD vdd_1v2.t0 sg13_lv_pmos ad=0.475p pd=2.88u as=0.475p ps=2.88u w=2.5u l=2u
X518 s5_an[1] ota_cmfb_top_0.dynamic_pcell$5_0.DRN_NET_CA vdd_1v2.t24 vdd_1v2.t0 sg13_lv_pmos ad=95f pd=0.88u as=0.17p ps=1.68u w=0.5u l=0.5u
X519 vss_1v2.t260 vss_1v2.t259 ota_cmfb_top_0.ota_cmfb_core_push_pull_output_stage_0/dynamic_pcell$4_0.SRC_NET_ML vss_1v2.t210 sg13_lv_nmos ad=0.133p pd=1.08u as=0.133p ps=1.08u w=0.7u l=0.5u
X520 vss_1v2.t158 vss_1v2.t156 vss_1v2.t157 vss_1v2.t149 sg13_lv_nmos ad=0.238p pd=2.08u as=0 ps=0 w=0.7u l=0.5u
X521 vdd_1v2.t288 vdd_1v2.t286 vdd_1v2.t287 vdd_1v2.t0 sg13_lv_pmos ad=0.85p pd=5.68u as=0 ps=0 w=2.5u l=0.5u
X522 ota_cmfb_top_0.ota_cmfb_core_push_pull_output_stage_1/dynamic_pcell$4_0.SRC_NET_IJ_GATE_DI ota_cmfb_top_0.ota_cmfb_core_push_pull_output_stage_1/dynamic_pcell$4_0.SRC_NET_IJ_GATE_DI ota_cmfb_top_0.ota_cmfb_core_push_pull_output_stage_1/dynamic_pcell$4_0.DRN_NET_HI vdd_1v2.t0 sg13_lv_pmos ad=0.85p pd=5.68u as=0.475p ps=2.88u w=2.5u l=3u
X523 ota_cmfb_top_0.ota_cmfb_core_push_pull_output_stage_1/dynamic_pcell$4_0.DRN_NET_HI ota_cmfb_top_0.dynamic_pcell$5_0.G_DRN vdd_1v2.t4 vdd_1v2.t0 sg13_lv_pmos ad=0.475p pd=2.88u as=0.85p ps=5.68u w=2.5u l=3u
X524 vss_1v2.t74 ota_cmfb_top_0.dynamic_pcell$5_0.Gate ota_cmfb_top_0.dynamic_pcell$5_0.DRN_NET_JL.t3 vss_1v2.t318 sg13_lv_nmos ad=62.5f pd=0.74u as=62.5f ps=0.74u w=0.25u l=10u
X525 a_50924_27979# a_50660_27693# vss_1v2.t10 rhigh l=1u w=0.5u
X526 vdd_1v2.t74 vdd_1v2.t72 vdd_1v2.t71 vdd_1v2.t0 sg13_lv_pmos ad=0.2375p pd=1.63u as=0 ps=0 w=1.25u l=0.5u
X527 a_58666_33917# a_58402_33631# vss_1v2.t13 rhigh l=1u w=0.5u
X528 vdd_1v2.t80 vdd_1v2.t78 vdd_1v2.t77 vdd_1v2.t0 sg13_lv_pmos ad=0.2375p pd=1.63u as=0 ps=0 w=1.25u l=0.5u
X529 vdd_1v2.t249 vdd_1v2.t64 vdd_1v2.t251 vdd_1v2.t0 sg13_lv_pmos ad=95f pd=0.88u as=0 ps=0 w=0.5u l=0.5u
X530 ota_cmfb_top_0.ota_cmfb_core_push_pull_output_stage_1/dynamic_pcell$4_0.B_DRN ota_cmfb_top_0.ota_cmfb_core_push_pull_output_stage_1/dynamic_pcell$4_0.B_DRN ota_cmfb_top_0.ota_cmfb_core_push_pull_output_stage_1/dynamic_pcell$4_0.DRN_NET_OP_GATE_MP vss_1v2.t27 sg13_lv_nmos ad=0.133p pd=1.08u as=0.133p ps=1.08u w=0.7u l=3u
X531 vdd_1v2.t11 ota_cmfb_top_0.dynamic_pcell$5_0.G_DRN ota_cmfb_top_0.dynamic_pcell$5_0.G_DRN.t4 vdd_1v2.t0 sg13_lv_pmos ad=0.475p pd=2.88u as=0.475p ps=2.88u w=2.5u l=3u
X532 ota_cmfb_top_0.dynamic_pcell$5_0.DRN_NET_BD ota_cmfb_top_0.dynamic_pcell$5_0.DRN_NET_E_GATE_CDEFGH vss_1v2.t132 vss_1v2.t33 sg13_lv_nmos ad=62.5f pd=0.74u as=62.5f ps=0.74u w=0.25u l=10u
X533 vdd_1v2.t14 ota_cmfb_top_0.dynamic_pcell$5_0.G_DRN ota_cmfb_top_0.dynamic_pcell$5_0.G_DRN.t9 vdd_1v2.t0 sg13_lv_pmos ad=0.475p pd=2.88u as=0.475p ps=2.88u w=2.5u l=3u
X534 vdd_1v2.t23 ota_cmfb_top_0.dynamic_pcell$5_0.H_DRN.t5 ota_cmfb_top_0.dynamic_pcell$5_0.H_DRN.t1 vdd_1v2.t0 sg13_lv_pmos ad=0.2375p pd=1.63u as=0.2375p ps=1.63u w=1.25u l=5u
X535 vdd_1v2.t197 vdd_1v2.t199 vdd_1v2.t200 vdd_1v2.t0 sg13_lv_pmos ad=0.475p pd=2.88u as=0 ps=0 w=2.5u l=0.5u
X536 vdd_1v2.t168 vdd_1v2.t153 vdd_1v2.t170 vdd_1v2.t0 sg13_lv_pmos ad=95f pd=0.88u as=0 ps=0 w=0.5u l=0.5u
X537 ota_cmfb_top_0.ota_cmfb_core_push_pull_output_stage_0/dynamic_pcell$4_0.DRN_NET_MENX vss_1v2.t231 vss_1v2.t232 vss_1v2.t1 sg13_lv_nmos ad=0.133p pd=1.08u as=0.133p ps=1.08u w=0.7u l=3u
X538 ota_cmfb_top_0.ota_cmfb_core_push_pull_output_stage_1/dynamic_pcell$4_0.SRC_NET_ML ota_cmfb_top_0.ota_cmfb_core_push_pull_output_stage_1/dynamic_pcell$4_0.DRN_NET_OP_GATE_MP ota_cmfb_top_0.ota_cmfb_core_push_pull_output_stage_1/dynamic_pcell$4_0.DRN_NET_MENX vss_1v2.t29 sg13_lv_nmos ad=0.133p pd=1.08u as=0.133p ps=1.08u w=0.7u l=3u
X539 vdd_1v2.t447 ota_cmfb_top_0.dynamic_pcell$5_0.F_DRN ota_cmfb_top_0.dynamic_pcell$5_0.F_DRN.t10 vdd_1v2.t0 sg13_lv_pmos ad=0.475p pd=2.88u as=0.475p ps=2.88u w=2.5u l=3u
X540 ota_cmfb_top_0.dynamic_pcell$5_0.DRN_NET_CA ota_cmfb_top_0.dynamic_pcell$5_0.DRN_NET_E_GATE_CDEFGH vss_1v2.t85 vss_1v2.t33 sg13_lv_nmos ad=62.5f pd=0.74u as=62.5f ps=0.74u w=0.25u l=10u
X541 ota_cmfb_top_0.ota_cmfb_core_push_pull_output_stage_1/dynamic_pcell$4_0.SRC_NET_ML ota_cmfb_top_0.ota_cmfb_core_push_pull_output_stage_1/dynamic_pcell$4_0.DRN_NET_OP_GATE_MP ota_cmfb_top_0.ota_cmfb_core_push_pull_output_stage_1/dynamic_pcell$4_0.DRN_NET_MENX vss_1v2.t19 sg13_lv_nmos ad=0.133p pd=1.08u as=0.133p ps=1.08u w=0.7u l=3u
X542 ota_cmfb_top_0.ota_cmfb_core_push_pull_output_stage_0/dynamic_pcell$4_0.SRC_NET_IJ_GATE_DI vdd_1v2.t383 vdd_1v2.t375 vdd_1v2.t0 sg13_lv_pmos ad=0.475p pd=2.88u as=0.475p ps=2.88u w=2.5u l=0.5u
X543 vdd_1v2.t104 vdd_1v2.t102 vdd_1v2.t103 vdd_1v2.t0 sg13_lv_pmos ad=0.2375p pd=1.63u as=0 ps=0 w=1.25u l=0.5u
X544 a_52197_34440# w_52782_33612# vss_1v2.t32 rhigh l=1u w=0.5u
X545 vss_1v2.t116 vss_1v2.t117 ota_cmfb_top_0.dynamic_pcell$5_0.DRN_NET_E_GATE_CDEFGH.t3 vss_1v2.t73 sg13_lv_nmos ad=62.5f pd=0.74u as=62.5f ps=0.74u w=0.25u l=0.5u
X546 ota_cmfb_top_0.EN_INV_1/sg13cmos5l_inv_4_0.Y enable.t3 vdd_1v2.t401 vdd_1v2.t0 sg13_lv_pmos ad=0.2128p pd=1.5u as=0.2128p ps=1.5u w=1.12u l=0.13u
C0 a_49340_27218# a_49340_27132# 0.01257f
C1 ota_cmfb_top_0.ota_cmfb_core_push_pull_output_stage_1/dynamic_pcell$4_0.DRN_NET_OP_GATE_MP ota_cmfb_top_0.dynamic_pcell$5_0.F_DRN 0.10016f
C2 a_49604_27418# a_50132_27418# 0.01672f
C3 ota_cmfb_top_0.dynamic_pcell$5_0.F_DRN ota_cmfb_top_0.dynamic_pcell$5_0.DRN_NET_E_GATE_CDEFGH 2.58531f
C4 a_49076_27779# a_49340_27779# 0.02325f
C5 s5_an[0] ota_cmfb_top_0.dynamic_pcell$5_0.DRN_NET_BD 0.03837f
C6 ota_cmfb_top_0.ota_cmfb_core_push_pull_output_stage_1/dynamic_pcell$4_0.SRC_NET_IJ_GATE_DI ota_cmfb_top_0.ota_cmfb_core_push_pull_output_stage_1/dynamic_pcell$4_0.B_DRN 1.71592f
C7 ota_cmfb_top_0.dynamic_pcell$5_0.DRN_NET_CA ota_cmfb_top_0.dynamic_pcell$5_0.Gate 1.11652f
C8 ota_cmfb_top_0.dynamic_pcell$5_0.DRN_NET_JL ota_cmfb_top_0.dynamic_pcell$5_0.G_DRN 0.0576f
C9 vdd_1v2 a_58402_34440# 0.03027f
C10 a_48812_27979# a_49340_27979# 0.01672f
C11 vdd_1v2 s5_an[2] 11.6458f
C12 enable ota_cmfb_top_0.ota_cmfb_core_push_pull_output_stage_1/dynamic_pcell$4_0.DRN_NET_MENX 0.03146f
C13 ota_cmfb_top_0.ota_cmfb_core_push_pull_output_stage_1/dynamic_pcell$4_0.SRC_NET_ML ota_cmfb_top_0.ota_cmfb_core_push_pull_output_stage_1/dynamic_pcell$4_0.DRN_NET_J_GATE_EJ 0.05576f
C14 m3_0_20487# slot5_wrapper_0.ibias1 0.15943f
C15 a_51188_27218# s5_an[1] 0.02048f
C16 ota_cmfb_top_0.dynamic_pcell$5_0.L_GATE ota_cmfb_top_0.EN_INV_1/sg13cmos5l_inv_4_0.Y 0.14674f
C17 s5_an[2] a_58402_33917# 0.01687f
C18 a_50132_27218# a_50132_27418# 0.01257f
C19 slot5_wrapper_0.dig_in[6] slot5_wrapper_0.dig_in[5] 0.23029f
C20 enable ota_cmfb_top_0.dynamic_pcell$5_0.H_DRN 0.09313f
C21 ota_cmfb_top_0.ota_cmfb_core_push_pull_output_stage_0/dynamic_pcell$4_0.SRC_NET_IJ_GATE_DI vdd_1v2 17.5609f
C22 w_59515_33612# ota_cmfb_top_0.dynamic_pcell$5_0.DRN_NET_BD 9.51613f
C23 slot5_wrapper_0.reset slot5_wrapper_0.dig_in[23] 0.23029f
C24 analog_bus1 ota_cmfb_top_0.dynamic_pcell$5_0.Gate 1.74332f
C25 slot5_wrapper_0.dig_in[10] slot5_wrapper_0.dig_in[9] 0.23029f
C26 s5_an[1] ota_cmfb_top_0.ota_cmfb_core_push_pull_output_stage_1/dynamic_pcell$4_0.DRN_NET_MENX 0.24656f
C27 s5_an[0] ota_cmfb_top_0.dynamic_pcell$5_0.DRN_NET_CA 0.03423f
C28 ota_cmfb_top_0.dynamic_pcell$5_0.Gate ota_cmfb_top_0.dynamic_pcell$5_0.F_DRN 0.03763f
C29 a_59194_34240# ota_cmfb_top_0.dynamic_pcell$5_0.DRN_NET_BD 0.01075f
C30 a_58402_33631# a_58930_33631# 0.01672f
C31 a_58666_33917# a_58930_33717# 0.01257f
C32 enable ota_cmfb_top_0.dynamic_pcell$5_0.DRN_NET_BD 5.09712f
C33 enable a_45783_27500# 0.03634f
C34 w_52782_33612# a_52197_34440# 0.01802f
C35 ota_cmfb_top_0.ota_cmfb_core_push_pull_output_stage_0/dynamic_pcell$4_0.DRN_NET_CD ota_cmfb_top_0.ota_cmfb_core_push_pull_output_stage_0/dynamic_pcell$4_0.DRN_NET_J_GATE_EJ 0.11586f
C36 ota_cmfb_top_0.ota_cmfb_core_push_pull_output_stage_0/dynamic_pcell$4_0.B_DRN ota_cmfb_top_0.ota_cmfb_core_push_pull_output_stage_0/dynamic_pcell$4_0.DRN_NET_HI 0.03502f
C37 ota_cmfb_top_0.ota_cmfb_core_push_pull_output_stage_1/dynamic_pcell$4_0.DRN_NET_CD ota_cmfb_top_0.ota_cmfb_core_push_pull_output_stage_1/dynamic_pcell$4_0.DRN_NET_HI 0.04326f
C38 slot5_wrapper_0.dig_in[14] slot5_wrapper_0.dig_in[13] 0.23029f
C39 ota_cmfb_top_0.dynamic_pcell$5_0.SRC_NET_KL ota_cmfb_top_0.dynamic_pcell$5_0.L_GATE 0.5844f
C40 s5_an[1] ota_cmfb_top_0.dynamic_pcell$5_0.H_DRN 0.011f
C41 a_50924_27218# a_50924_27132# 0.01257f
C42 ota_cmfb_top_0.dynamic_pcell$5_0.G_DRN ota_cmfb_top_0.ota_cmfb_core_push_pull_output_stage_1/dynamic_pcell$4_0.DRN_NET_J_GATE_EJ 1.35323f
C43 slot5_wrapper_0.dig_in[18] slot5_wrapper_0.dig_in[17] 0.23029f
C44 ota_cmfb_top_0.ota_cmfb_core_push_pull_output_stage_1/dynamic_pcell$4_0.SRC_NET_IJ_GATE_DI ota_cmfb_top_0.ota_cmfb_core_push_pull_output_stage_1/dynamic_pcell$4_0.DRN_NET_CD 6.08314f
C45 ota_cmfb_top_0.ota_cmfb_core_push_pull_output_stage_0/dynamic_pcell$4_0.DRN_NET_MENX s5_an[1] 0.05081f
C46 m3_0_22251# analog_bus1 0.16363f
C47 analog_bus0 ota_cmfb_top_0.dynamic_pcell$5_0.Gate 0.06849f
C48 ota_cmfb_top_0.ota_cmfb_core_push_pull_output_stage_1/dynamic_pcell$4_0.B_DRN ota_cmfb_top_0.ota_cmfb_core_push_pull_output_stage_1/dynamic_pcell$4_0.DRN_NET_MENX 0.78705f
C49 s5_an[0] analog_bus1 0.24007f
C50 s5_an[1] ota_cmfb_top_0.dynamic_pcell$5_0.DRN_NET_BD 0.13815f
C51 a_51933_34240# a_51933_34154# 0.01257f
C52 s5_an[0] ota_cmfb_top_0.dynamic_pcell$5_0.F_DRN 0.03255f
C53 slot5_wrapper_0.dig_in[22] slot5_wrapper_0.dig_in[21] 0.23029f
C54 ota_cmfb_top_0.ota_cmfb_core_push_pull_output_stage_0/dynamic_pcell$4_0.Gate ota_cmfb_top_0.ota_cmfb_core_push_pull_output_stage_0/dynamic_pcell$4_0.DRN_NET_OP_GATE_MP 6.19095f
C55 enable ota_cmfb_top_0.dynamic_pcell$5_0.DRN_NET_CA 1.49723f
C56 vdd_1v2 a_58402_33631# 0.05193f
C57 ota_cmfb_top_0.ota_cmfb_core_push_pull_output_stage_1/dynamic_pcell$4_0.DRN_NET_OP_GATE_MP vdd_1v2 0.01945f
C58 a_58402_34240# a_58666_34240# 0.02325f
C59 s5_an[2] a_58666_34154# 0.11127f
C60 ota_cmfb_top_0.ota_cmfb_core_push_pull_output_stage_0/dynamic_pcell$4_0.DRN_NET_J_GATE_EJ ota_cmfb_top_0.ota_cmfb_core_push_pull_output_stage_0/dynamic_pcell$4_0.Gate 6.88681f
C61 vdd_1v2 ota_cmfb_top_0.dynamic_pcell$5_0.DRN_NET_E_GATE_CDEFGH 0.08227f
C62 ota_cmfb_top_0.dynamic_pcell$5_0.L_GATE a_48812_27218# 0.01681f
C63 s5_an[2] a_58666_33717# 0.01411f
C64 a_49868_27979# a_49868_27779# 0.01257f
C65 slot5_wrapper_0.analog_bus2 m3_0_21075# 0.15943f
C66 a_50132_27693# a_50396_27779# 0.01257f
C67 ota_cmfb_top_0.ota_cmfb_core_push_pull_output_stage_0/EN_INV_0/sg13cmos5l_inv_4_0.Y enable 0.35065f
C68 vdd_1v2 a_52197_34440# 0.03411f
C69 a_50660_27779# a_50924_27779# 0.02325f
C70 analog_bus0 m3_0_22251# 0.15943f
C71 ota_cmfb_top_0.dynamic_pcell$5_0.DRN_NET_BD ota_cmfb_top_0.ota_cmfb_core_push_pull_output_stage_1/dynamic_pcell$4_0.B_DRN 0.02593f
C72 analog_bus0 s5_an[0] 0.21521f
C73 ota_cmfb_top_0.ota_cmfb_core_push_pull_output_stage_0/dynamic_pcell$4_0.DRN_NET_CD ota_cmfb_top_0.ota_cmfb_core_push_pull_output_stage_0/dynamic_pcell$4_0.DRN_NET_HI 0.04429f
C74 ota_cmfb_top_0.ota_cmfb_core_push_pull_output_stage_1/dynamic_pcell$4_0.Gate s5_an[1] 0.05833f
C75 s5_an[1] ota_cmfb_top_0.dynamic_pcell$5_0.DRN_NET_CA 0.73009f
C76 enable analog_bus1 0.40791f
C77 ota_cmfb_top_0.dynamic_pcell$5_0.SRC_NET_AB ota_cmfb_top_0.dynamic_pcell$5_0.Gate 0.59718f
C78 a_49076_27218# a_49340_27218# 0.02325f
C79 enable ota_cmfb_top_0.dynamic_pcell$5_0.F_DRN 0.24439f
C80 ota_cmfb_top_0.ota_cmfb_core_push_pull_output_stage_1/EN_INV_0/sg13cmos5l_inv_4_0.Y enable 0.35101f
C81 a_51669_33631# a_52197_33631# 0.01672f
C82 a_51933_33917# a_52197_33717# 0.01257f
C83 ota_cmfb_top_0.ota_cmfb_core_push_pull_output_stage_0/dynamic_pcell$4_0.DRN_NET_J_GATE_EJ ota_cmfb_top_0.ota_cmfb_core_push_pull_output_stage_0/dynamic_pcell$4_0.DRN_NET_OP_GATE_MP 0.28979f
C84 vdd_1v2 a_51669_33631# 0.06185f
C85 a_49604_27418# a_49868_27218# 0.01257f
C86 a_49340_27132# a_49868_27132# 0.01672f
C87 ota_cmfb_top_0.dynamic_pcell$5_0.G_DRN ota_cmfb_top_0.ota_cmfb_core_push_pull_output_stage_1/dynamic_pcell$4_0.DRN_NET_HI 4.57567f
C88 a_49076_27779# a_49076_27693# 0.01257f
C89 vdd_1v2 a_49340_27979# 0.05377f
C90 ota_cmfb_top_0.ota_cmfb_core_push_pull_output_stage_0/dynamic_pcell$4_0.B_DRN ota_cmfb_top_0.ota_cmfb_core_push_pull_output_stage_0/dynamic_pcell$4_0.DRN_NET_MENX 0.78705f
C91 ota_cmfb_top_0.ota_cmfb_core_push_pull_output_stage_0/EN_INV_0/sg13cmos5l_inv_4_0.Y s5_an[1] 0.09535f
C92 vdd_1v2 ota_cmfb_top_0.dynamic_pcell$5_0.Gate 2.48558f
C93 a_48812_27979# a_49076_27779# 0.01257f
C94 vdd_1v2 ota_cmfb_top_0.EN_INV_0/sg13cmos5l_inv_4_0.Y 0.4623f
C95 ota_cmfb_top_0.ota_cmfb_core_push_pull_output_stage_1/dynamic_pcell$4_0.DRN_NET_CD ota_cmfb_top_0.ota_cmfb_core_push_pull_output_stage_1/dynamic_pcell$4_0.DRN_NET_MENX 0.04205f
C96 ota_cmfb_top_0.ota_cmfb_core_push_pull_output_stage_1/dynamic_pcell$4_0.DRN_NET_J_GATE_EJ ota_cmfb_top_0.ota_cmfb_core_push_pull_output_stage_1/dynamic_pcell$4_0.DRN_NET_HI 2.92898f
C97 ibias0 vdd_1v2 6.47284f
C98 ota_cmfb_top_0.ota_cmfb_core_push_pull_output_stage_0/dynamic_pcell$4_0.B_DRN ota_cmfb_top_0.dynamic_pcell$5_0.DRN_NET_BD 2.63727f
C99 ota_cmfb_top_0.dynamic_pcell$5_0.G_DRN ota_cmfb_top_0.ota_cmfb_core_push_pull_output_stage_1/dynamic_pcell$4_0.SRC_NET_IJ_GATE_DI 2.26021f
C100 ota_cmfb_top_0.EN_INV_1/sg13cmos5l_inv_4_0.Y ota_cmfb_top_0.dynamic_pcell$5_0.DRN_NET_E_GATE_CDEFGH 0.01652f
C101 s5_an[2] a_58402_34440# 0.04226f
C102 ota_cmfb_top_0.ota_cmfb_core_push_pull_output_stage_1/dynamic_pcell$4_0.Gate ota_cmfb_top_0.ota_cmfb_core_push_pull_output_stage_1/dynamic_pcell$4_0.B_DRN 0.76295f
C103 ota_cmfb_top_0.dynamic_pcell$5_0.DRN_NET_CA ota_cmfb_top_0.ota_cmfb_core_push_pull_output_stage_1/dynamic_pcell$4_0.B_DRN 2.68254f
C104 m5_15730_46988# m5_18580_46988# 0.31443f
C105 ota_cmfb_top_0.ota_cmfb_core_push_pull_output_stage_1/dynamic_pcell$4_0.SRC_NET_IJ_GATE_DI ota_cmfb_top_0.ota_cmfb_core_push_pull_output_stage_1/dynamic_pcell$4_0.DRN_NET_J_GATE_EJ 5.83093f
C106 s5_an[1] ota_cmfb_top_0.dynamic_pcell$5_0.F_DRN 0.3487f
C107 ota_cmfb_top_0.ota_cmfb_core_push_pull_output_stage_1/EN_INV_0/sg13cmos5l_inv_4_0.Y s5_an[1] 0.09535f
C108 a_50132_27218# a_49868_27218# 0.02325f
C109 s5_an[0] ota_cmfb_top_0.dynamic_pcell$5_0.SRC_NET_AB 1.9876f
C110 ota_cmfb_top_0.ota_cmfb_core_push_pull_output_stage_1/dynamic_pcell$4_0.SRC_NET_ML ota_cmfb_top_0.ota_cmfb_core_push_pull_output_stage_1/dynamic_pcell$4_0.DRN_NET_MENX 2.93711f
C111 enable w_52782_33612# 0.01081f
C112 w_59515_33612# a_58930_33631# 0.01194f
C113 slot5_wrapper_0.clk enable 0.23029f
C114 a_58930_34240# a_59194_34240# 0.02325f
C115 slot5_wrapper_0.dig_out[2] slot5_wrapper_0.dig_out[1] 0.23029f
C116 s5_an[0] vdd_1v2 2.93423f
C117 a_58402_33631# a_58666_33717# 0.01257f
C118 ota_cmfb_top_0.ota_cmfb_core_push_pull_output_stage_0/dynamic_pcell$4_0.SRC_NET_IJ_GATE_DI s5_an[2] 0.18208f
C119 ota_cmfb_top_0.dynamic_pcell$5_0.DRN_NET_BD ota_cmfb_top_0.ota_cmfb_core_push_pull_output_stage_1/dynamic_pcell$4_0.DRN_NET_CD 0.02878f
C120 a_58930_33631# a_59194_33717# 0.01257f
C121 ota_cmfb_top_0.dynamic_pcell$5_0.H_DRN ota_cmfb_top_0.dynamic_pcell$5_0.DRN_NET_JL 0.45948f
C122 slot5_wrapper_0.dig_out[6] slot5_wrapper_0.dig_out[5] 0.23029f
C123 ota_cmfb_top_0.dynamic_pcell$5_0.F_DRN ota_cmfb_top_0.ota_cmfb_core_push_pull_output_stage_1/dynamic_pcell$4_0.B_DRN 0.02913f
C124 ota_cmfb_top_0.ota_cmfb_core_push_pull_output_stage_1/EN_INV_0/sg13cmos5l_inv_4_0.Y ota_cmfb_top_0.ota_cmfb_core_push_pull_output_stage_1/dynamic_pcell$4_0.B_DRN 0.03802f
C125 m5_84452_13191# m5_88802_13191# 0.534f
C126 enable a_51669_33917# 0.02157f
C127 s5_an[1] w_52782_33612# 0.07344f
C128 a_50660_27218# a_50924_27218# 0.02325f
C129 ota_cmfb_top_0.dynamic_pcell$5_0.L_GATE ota_cmfb_top_0.dynamic_pcell$5_0.DRN_NET_E_GATE_CDEFGH 0.16054f
C130 slot5_wrapper_0.dig_out[10] slot5_wrapper_0.dig_out[9] 0.23029f
C131 ota_cmfb_top_0.ota_cmfb_core_push_pull_output_stage_0/dynamic_pcell$4_0.DRN_NET_CD ota_cmfb_top_0.ota_cmfb_core_push_pull_output_stage_0/dynamic_pcell$4_0.DRN_NET_MENX 0.04216f
C132 ota_cmfb_top_0.ota_cmfb_core_push_pull_output_stage_0/dynamic_pcell$4_0.DRN_NET_J_GATE_EJ ota_cmfb_top_0.ota_cmfb_core_push_pull_output_stage_0/dynamic_pcell$4_0.DRN_NET_HI 2.936f
C133 ota_cmfb_top_0.ota_cmfb_core_push_pull_output_stage_0/dynamic_pcell$4_0.B_DRN ota_cmfb_top_0.ota_cmfb_core_push_pull_output_stage_0/EN_INV_0/sg13cmos5l_inv_4_0.Y 0.03802f
C134 ota_cmfb_top_0.dynamic_pcell$5_0.DRN_NET_JL ota_cmfb_top_0.dynamic_pcell$5_0.DRN_NET_BD 0.19504f
C135 w_52782_33612# a_52461_33717# 0.01719f
C136 vdd_1v2 w_59515_33612# 2.06153f
C137 ota_cmfb_top_0.ota_cmfb_core_push_pull_output_stage_0/dynamic_pcell$4_0.DRN_NET_CD ota_cmfb_top_0.dynamic_pcell$5_0.DRN_NET_BD 4.72903f
C138 a_51669_34440# a_52197_34440# 0.01672f
C139 slot5_wrapper_0.dig_in[2] slot5_wrapper_0.dig_in[1] 0.23029f
C140 ota_cmfb_top_0.dynamic_pcell$5_0.G_DRN ota_cmfb_top_0.ota_cmfb_core_push_pull_output_stage_1/dynamic_pcell$4_0.DRN_NET_MENX 0.13609f
C141 ota_cmfb_top_0.dynamic_pcell$5_0.DRN_NET_CA ota_cmfb_top_0.ota_cmfb_core_push_pull_output_stage_1/dynamic_pcell$4_0.DRN_NET_CD 4.90958f
C142 a_52197_34440# a_52461_34240# 0.01257f
C143 vdd_1v2 enable 15.0148f
C144 ota_cmfb_top_0.ota_cmfb_core_push_pull_output_stage_1/dynamic_pcell$4_0.SRC_NET_IJ_GATE_DI ota_cmfb_top_0.ota_cmfb_core_push_pull_output_stage_1/dynamic_pcell$4_0.DRN_NET_HI 3.70827f
C145 ota_cmfb_top_0.ota_cmfb_core_push_pull_output_stage_0/dynamic_pcell$4_0.B_DRN ota_cmfb_top_0.dynamic_pcell$5_0.F_DRN 6.08486f
C146 ota_cmfb_top_0.ota_cmfb_core_push_pull_output_stage_1/dynamic_pcell$4_0.DRN_NET_J_GATE_EJ ota_cmfb_top_0.ota_cmfb_core_push_pull_output_stage_1/dynamic_pcell$4_0.DRN_NET_MENX 7.39861f
C147 s5_an[2] a_58402_33631# 0.04352f
C148 ota_cmfb_top_0.dynamic_pcell$5_0.SRC_NET_KL ota_cmfb_top_0.dynamic_pcell$5_0.Gate 1.68329f
C149 ota_cmfb_top_0.dynamic_pcell$5_0.H_DRN ota_cmfb_top_0.dynamic_pcell$5_0.G_DRN 0.10057f
C150 ota_cmfb_top_0.ota_cmfb_core_push_pull_output_stage_1/dynamic_pcell$4_0.Gate ota_cmfb_top_0.ota_cmfb_core_push_pull_output_stage_1/dynamic_pcell$4_0.SRC_NET_ML 1.80938f
C151 ota_cmfb_top_0.ota_cmfb_core_push_pull_output_stage_1/dynamic_pcell$4_0.SRC_NET_ML ota_cmfb_top_0.dynamic_pcell$5_0.DRN_NET_CA 0.02128f
C152 ota_cmfb_top_0.dynamic_pcell$5_0.L_GATE ota_cmfb_top_0.dynamic_pcell$5_0.Gate 0.61696f
C153 a_50660_27779# a_50660_27693# 0.01257f
C154 ota_cmfb_top_0.dynamic_pcell$5_0.DRN_NET_JL ota_cmfb_top_0.dynamic_pcell$5_0.DRN_NET_CA 1.56361f
C155 ota_cmfb_top_0.dynamic_pcell$5_0.L_GATE ota_cmfb_top_0.EN_INV_0/sg13cmos5l_inv_4_0.Y 0.14067f
C156 ota_cmfb_top_0.ota_cmfb_core_push_pull_output_stage_0/dynamic_pcell$4_0.DRN_NET_MENX ota_cmfb_top_0.ota_cmfb_core_push_pull_output_stage_0/dynamic_pcell$4_0.Gate 0.59533f
C157 vdd_1v2 a_49868_27979# 0.05377f
C158 s5_an[1] a_52197_33631# 0.06347f
C159 ota_cmfb_top_0.dynamic_pcell$5_0.DRN_NET_JL a_48812_27979# 0.0104f
C160 vdd_1v2 s5_an[1] 6.88982f
C161 ota_cmfb_top_0.ota_cmfb_core_push_pull_output_stage_0/dynamic_pcell$4_0.Gate ota_cmfb_top_0.dynamic_pcell$5_0.DRN_NET_BD 0.04945f
C162 ota_cmfb_top_0.dynamic_pcell$5_0.DRN_NET_BD ota_cmfb_top_0.dynamic_pcell$5_0.G_DRN 0.82835f
C163 a_49076_27418# a_49076_27218# 0.01257f
C164 a_51669_33631# a_51933_33717# 0.01257f
C165 ota_cmfb_top_0.ota_cmfb_core_push_pull_output_stage_0/dynamic_pcell$4_0.B_DRN ota_cmfb_top_0.ota_cmfb_core_push_pull_output_stage_0/dynamic_pcell$4_0.SRC_NET_ML 0.42237f
C166 a_49340_27132# a_49604_27218# 0.01257f
C167 a_52197_33631# a_52461_33717# 0.01257f
C168 ota_cmfb_top_0.dynamic_pcell$5_0.DRN_NET_BD ota_cmfb_top_0.ota_cmfb_core_push_pull_output_stage_1/dynamic_pcell$4_0.DRN_NET_J_GATE_EJ 0.33729f
C169 slot5_wrapper_0.dig_in[7] slot5_wrapper_0.dig_in[6] 0.23029f
C170 a_48812_27779# a_49076_27779# 0.02325f
C171 s5_an[0] ota_cmfb_top_0.dynamic_pcell$5_0.SRC_NET_KL 0.53308f
C172 a_49340_27979# a_49604_27779# 0.01257f
C173 enable ota_cmfb_top_0.EN_INV_1/sg13cmos5l_inv_4_0.Y 0.38822f
C174 ota_cmfb_top_0.ota_cmfb_core_push_pull_output_stage_0/dynamic_pcell$4_0.DRN_NET_MENX ota_cmfb_top_0.ota_cmfb_core_push_pull_output_stage_0/dynamic_pcell$4_0.DRN_NET_OP_GATE_MP 5.62824f
C175 analog_bus1 ota_cmfb_top_0.dynamic_pcell$5_0.DRN_NET_JL 0.08085f
C176 ota_cmfb_top_0.ota_cmfb_core_push_pull_output_stage_1/dynamic_pcell$4_0.SRC_NET_ML ota_cmfb_top_0.dynamic_pcell$5_0.F_DRN 0.60054f
C177 slot5_wrapper_0.dig_in[11] slot5_wrapper_0.dig_in[10] 0.23029f
C178 s5_an[0] ota_cmfb_top_0.dynamic_pcell$5_0.L_GATE 0.12532f
C179 ota_cmfb_top_0.dynamic_pcell$5_0.DRN_NET_JL ota_cmfb_top_0.dynamic_pcell$5_0.F_DRN 0.05479f
C180 a_50660_27418# s5_an[1] 0.02295f
C181 ota_cmfb_top_0.ota_cmfb_core_push_pull_output_stage_0/dynamic_pcell$4_0.DRN_NET_OP_GATE_MP ota_cmfb_top_0.dynamic_pcell$5_0.DRN_NET_BD 0.04023f
C182 a_50660_27418# a_50660_27693# 0.0607f
C183 m5_11380_46988r# m5_15730_46988# 0.08443f
C184 vdd_1v2 ota_cmfb_top_0.ota_cmfb_core_push_pull_output_stage_1/dynamic_pcell$4_0.B_DRN 6.04001f
C185 ota_cmfb_top_0.ota_cmfb_core_push_pull_output_stage_0/dynamic_pcell$4_0.DRN_NET_J_GATE_EJ ota_cmfb_top_0.ota_cmfb_core_push_pull_output_stage_0/dynamic_pcell$4_0.DRN_NET_MENX 7.45311f
C186 ota_cmfb_top_0.ota_cmfb_core_push_pull_output_stage_0/dynamic_pcell$4_0.DRN_NET_CD ota_cmfb_top_0.dynamic_pcell$5_0.F_DRN 3.46067f
C187 slot5_wrapper_0.dig_in[15] slot5_wrapper_0.dig_in[14] 0.23029f
C188 w_59515_33612# a_58666_34154# 0.01701f
C189 m3_0_18723# slot5_wrapper_0.clk 0.01706f
C190 ota_cmfb_top_0.ota_cmfb_core_push_pull_output_stage_1/dynamic_pcell$4_0.DRN_NET_HI ota_cmfb_top_0.ota_cmfb_core_push_pull_output_stage_1/dynamic_pcell$4_0.DRN_NET_MENX 0.09335f
C191 ota_cmfb_top_0.ota_cmfb_core_push_pull_output_stage_1/dynamic_pcell$4_0.Gate ota_cmfb_top_0.dynamic_pcell$5_0.G_DRN 0.02776f
C192 ota_cmfb_top_0.ota_cmfb_core_push_pull_output_stage_0/dynamic_pcell$4_0.DRN_NET_J_GATE_EJ ota_cmfb_top_0.dynamic_pcell$5_0.DRN_NET_BD 0.88051f
C193 ota_cmfb_top_0.dynamic_pcell$5_0.DRN_NET_CA ota_cmfb_top_0.dynamic_pcell$5_0.G_DRN 12.5845f
C194 a_50660_27418# a_50132_27418# 0.01672f
C195 a_58930_34440# a_58930_34240# 0.01257f
C196 ota_cmfb_top_0.ota_cmfb_core_push_pull_output_stage_1/dynamic_pcell$4_0.Gate ota_cmfb_top_0.ota_cmfb_core_push_pull_output_stage_1/dynamic_pcell$4_0.DRN_NET_J_GATE_EJ 6.88681f
C197 ota_cmfb_top_0.dynamic_pcell$5_0.DRN_NET_CA ota_cmfb_top_0.ota_cmfb_core_push_pull_output_stage_1/dynamic_pcell$4_0.DRN_NET_J_GATE_EJ 0.67943f
C198 slot5_wrapper_0.dig_in[19] slot5_wrapper_0.dig_in[18] 0.23029f
C199 ota_cmfb_top_0.ota_cmfb_core_push_pull_output_stage_1/dynamic_pcell$4_0.SRC_NET_IJ_GATE_DI ota_cmfb_top_0.ota_cmfb_core_push_pull_output_stage_1/dynamic_pcell$4_0.DRN_NET_MENX 0.13705f
C200 ota_cmfb_top_0.ota_cmfb_core_push_pull_output_stage_0/EN_INV_0/sg13cmos5l_inv_4_0.Y ota_cmfb_top_0.ota_cmfb_core_push_pull_output_stage_0/dynamic_pcell$4_0.Gate 0.01391f
C201 m5_27280_47738r# m5_31630_47138r# 0.2403f
C202 analog_bus0 ota_cmfb_top_0.dynamic_pcell$5_0.DRN_NET_JL 0.09711f
C203 a_58930_33717# a_58930_33631# 0.01257f
C204 ota_cmfb_top_0.ota_cmfb_core_push_pull_output_stage_0/dynamic_pcell$4_0.B_DRN vdd_1v2 6.33614f
C205 slot5_wrapper_0.dig_in[23] slot5_wrapper_0.dig_in[22] 0.23029f
C206 enable ota_cmfb_top_0.dynamic_pcell$5_0.L_GATE 0.14683f
C207 m5_81602_13191# m5_84452_13191# 0.31443f
C208 a_50660_27418# a_50660_27218# 0.01257f
C209 ota_cmfb_top_0.ota_cmfb_core_push_pull_output_stage_0/dynamic_pcell$4_0.Gate ota_cmfb_top_0.dynamic_pcell$5_0.F_DRN 0.2093f
C210 ota_cmfb_top_0.dynamic_pcell$5_0.DRN_NET_BD ota_cmfb_top_0.ota_cmfb_core_push_pull_output_stage_1/dynamic_pcell$4_0.DRN_NET_HI 0.23522f
C211 ota_cmfb_top_0.ota_cmfb_core_push_pull_output_stage_1/EN_INV_0/sg13cmos5l_inv_4_0.Y ota_cmfb_top_0.dynamic_pcell$5_0.G_DRN 0.03695f
C212 ota_cmfb_top_0.dynamic_pcell$5_0.G_DRN ota_cmfb_top_0.dynamic_pcell$5_0.F_DRN 2.30588f
C213 ota_cmfb_top_0.ota_cmfb_core_push_pull_output_stage_1/EN_INV_0/sg13cmos5l_inv_4_0.Y ota_cmfb_top_0.ota_cmfb_core_push_pull_output_stage_1/dynamic_pcell$4_0.DRN_NET_J_GATE_EJ 0.01107f
C214 ota_cmfb_top_0.dynamic_pcell$5_0.F_DRN ota_cmfb_top_0.ota_cmfb_core_push_pull_output_stage_1/dynamic_pcell$4_0.DRN_NET_J_GATE_EJ 0.04731f
C215 ota_cmfb_top_0.dynamic_pcell$5_0.DRN_NET_BD ota_cmfb_top_0.ota_cmfb_core_push_pull_output_stage_1/dynamic_pcell$4_0.SRC_NET_IJ_GATE_DI 0.53521f
C216 a_51669_34440# a_51933_34240# 0.01257f
C217 a_51669_34240# a_51669_33917# 0.01218f
C218 a_51933_34154# a_52197_34240# 0.01257f
C219 s5_an[2] w_59515_33612# 0.77045f
C220 vdd_1v2 ota_cmfb_top_0.ota_cmfb_core_push_pull_output_stage_1/dynamic_pcell$4_0.DRN_NET_CD 5.31796f
C221 ota_cmfb_top_0.ota_cmfb_core_push_pull_output_stage_0/dynamic_pcell$4_0.DRN_NET_HI ota_cmfb_top_0.ota_cmfb_core_push_pull_output_stage_0/dynamic_pcell$4_0.DRN_NET_MENX 0.09346f
C222 ota_cmfb_top_0.ota_cmfb_core_push_pull_output_stage_0/dynamic_pcell$4_0.DRN_NET_J_GATE_EJ ota_cmfb_top_0.ota_cmfb_core_push_pull_output_stage_0/EN_INV_0/sg13cmos5l_inv_4_0.Y 0.01107f
C223 ibias0 m3_0_19899# 0.15943f
C224 ota_cmfb_top_0.ota_cmfb_core_push_pull_output_stage_0/dynamic_pcell$4_0.DRN_NET_HI ota_cmfb_top_0.dynamic_pcell$5_0.DRN_NET_BD 0.27505f
C225 ota_cmfb_top_0.dynamic_pcell$5_0.DRN_NET_JL ota_cmfb_top_0.dynamic_pcell$5_0.SRC_NET_AB 3.03506f
C226 s5_an[2] a_59194_34240# 0.01599f
C227 ota_cmfb_top_0.ota_cmfb_core_push_pull_output_stage_0/dynamic_pcell$4_0.DRN_NET_OP_GATE_MP ota_cmfb_top_0.dynamic_pcell$5_0.F_DRN 0.12064f
C228 enable s5_an[2] 0.11636f
C229 slot5_wrapper_0.vss_3v3 slot5_wrapper_0.vdd_3v3 0.01435f
C230 ota_cmfb_top_0.ota_cmfb_core_push_pull_output_stage_0/dynamic_pcell$4_0.Gate ota_cmfb_top_0.ota_cmfb_core_push_pull_output_stage_0/dynamic_pcell$4_0.SRC_NET_ML 1.80938f
C231 s5_an[2] a_59194_33717# 0.02891f
C232 ota_cmfb_top_0.dynamic_pcell$5_0.Gate ota_cmfb_top_0.dynamic_pcell$5_0.DRN_NET_E_GATE_CDEFGH 4.71218f
C233 a_49868_27979# a_50396_27979# 0.01672f
C234 a_51933_34154# a_51933_33917# 0.07379f
C235 ota_cmfb_top_0.dynamic_pcell$5_0.DRN_NET_CA ota_cmfb_top_0.ota_cmfb_core_push_pull_output_stage_1/dynamic_pcell$4_0.DRN_NET_HI 0.15912f
C236 vdd_1v2 a_51669_34240# 0.01686f
C237 ota_cmfb_top_0.ota_cmfb_core_push_pull_output_stage_0/dynamic_pcell$4_0.DRN_NET_J_GATE_EJ ota_cmfb_top_0.dynamic_pcell$5_0.F_DRN 1.60884f
C238 ibias0 ota_cmfb_top_0.dynamic_pcell$5_0.DRN_NET_E_GATE_CDEFGH 0.1503f
C239 a_50396_27779# a_50660_27779# 0.02325f
C240 vdd_1v2 ota_cmfb_top_0.dynamic_pcell$5_0.DRN_NET_JL 49.4792f
C241 a_50924_27979# a_51188_27779# 0.01257f
C242 ota_cmfb_top_0.ota_cmfb_core_push_pull_output_stage_1/dynamic_pcell$4_0.Gate ota_cmfb_top_0.ota_cmfb_core_push_pull_output_stage_1/dynamic_pcell$4_0.SRC_NET_IJ_GATE_DI 0.02434f
C243 ota_cmfb_top_0.ota_cmfb_core_push_pull_output_stage_0/dynamic_pcell$4_0.DRN_NET_CD vdd_1v2 5.38577f
C244 ota_cmfb_top_0.dynamic_pcell$5_0.DRN_NET_CA ota_cmfb_top_0.ota_cmfb_core_push_pull_output_stage_1/dynamic_pcell$4_0.SRC_NET_IJ_GATE_DI 4.88319f
C245 m3_0_21075# slot5_wrapper_0.analog_bus3 0.15943f
C246 a_48812_27218# a_49076_27218# 0.02325f
C247 ota_cmfb_top_0.ota_cmfb_core_push_pull_output_stage_0/dynamic_pcell$4_0.SRC_NET_IJ_GATE_DI enable 0.07973f
C248 a_52197_33717# a_52197_33631# 0.01257f
C249 s5_an[1] s5_an[2] 0.24123f
C250 s5_an[2] a_50660_27693# 0.024f
C251 a_49868_27218# a_49868_27132# 0.01257f
C252 ota_cmfb_top_0.ota_cmfb_core_push_pull_output_stage_0/dynamic_pcell$4_0.DRN_NET_OP_GATE_MP ota_cmfb_top_0.ota_cmfb_core_push_pull_output_stage_0/dynamic_pcell$4_0.SRC_NET_ML 2.78684f
C253 a_49076_27693# a_49340_27779# 0.01257f
C254 s5_an[0] ota_cmfb_top_0.dynamic_pcell$5_0.DRN_NET_E_GATE_CDEFGH 0.02776f
C255 ota_cmfb_top_0.ota_cmfb_core_push_pull_output_stage_0/dynamic_pcell$4_0.DRN_NET_J_GATE_EJ ota_cmfb_top_0.ota_cmfb_core_push_pull_output_stage_0/dynamic_pcell$4_0.SRC_NET_ML 0.05576f
C256 slot5_wrapper_0.dig_out[3] slot5_wrapper_0.dig_out[2] 0.23029f
C257 ota_cmfb_top_0.dynamic_pcell$5_0.Gate ota_cmfb_top_0.EN_INV_0/sg13cmos5l_inv_4_0.Y 0.01859f
C258 ota_cmfb_top_0.dynamic_pcell$5_0.DRN_NET_BD ota_cmfb_top_0.ota_cmfb_core_push_pull_output_stage_1/dynamic_pcell$4_0.DRN_NET_MENX 0.05014f
C259 m5_7030_46988# m5_11380_46988r# 0.3738f
C260 a_58402_34240# a_58402_33917# 0.01218f
C261 slot5_wrapper_0.vbias m3_0_18723# 0.15943f
C262 slot5_wrapper_0.dig_out[7] slot5_wrapper_0.dig_out[6] 0.23029f
C263 ota_cmfb_top_0.ota_cmfb_core_push_pull_output_stage_0/dynamic_pcell$4_0.Gate vdd_1v2 0.04406f
C264 vdd_1v2 ota_cmfb_top_0.dynamic_pcell$5_0.G_DRN 52.1223f
C265 a_50396_27218# a_50132_27418# 0.01257f
C266 a_50396_27132# a_49868_27132# 0.01672f
C267 ota_cmfb_top_0.dynamic_pcell$5_0.DRN_NET_JL ota_cmfb_top_0.EN_INV_1/sg13cmos5l_inv_4_0.Y 0.02777f
C268 s5_an[2] ota_cmfb_top_0.ota_cmfb_core_push_pull_output_stage_1/dynamic_pcell$4_0.B_DRN 0.24647f
C269 a_58666_34240# a_58930_34240# 0.02325f
C270 ota_cmfb_top_0.dynamic_pcell$5_0.H_DRN ota_cmfb_top_0.dynamic_pcell$5_0.DRN_NET_BD 2.74139f
C271 vdd_1v2 ota_cmfb_top_0.ota_cmfb_core_push_pull_output_stage_1/dynamic_pcell$4_0.DRN_NET_J_GATE_EJ 14.6227f
C272 ota_cmfb_top_0.ota_cmfb_core_push_pull_output_stage_0/dynamic_pcell$4_0.DRN_NET_HI ota_cmfb_top_0.dynamic_pcell$5_0.F_DRN 4.57567f
C273 slot5_wrapper_0.dig_out[11] slot5_wrapper_0.dig_out[10] 0.23029f
C274 ota_cmfb_top_0.ota_cmfb_core_push_pull_output_stage_0/dynamic_pcell$4_0.DRN_NET_MENX ota_cmfb_top_0.dynamic_pcell$5_0.DRN_NET_BD 4.80749f
C275 a_58666_33717# a_58930_33717# 0.02325f
C276 enable ota_cmfb_top_0.dynamic_pcell$5_0.DRN_NET_E_GATE_CDEFGH 4.34638f
C277 s5_an[0] ota_cmfb_top_0.dynamic_pcell$5_0.Gate 4.18002f
C278 ota_cmfb_top_0.ota_cmfb_core_push_pull_output_stage_1/dynamic_pcell$4_0.Gate ota_cmfb_top_0.ota_cmfb_core_push_pull_output_stage_1/dynamic_pcell$4_0.DRN_NET_MENX 0.59533f
C279 ota_cmfb_top_0.dynamic_pcell$5_0.DRN_NET_CA ota_cmfb_top_0.ota_cmfb_core_push_pull_output_stage_1/dynamic_pcell$4_0.DRN_NET_MENX 4.80749f
C280 s5_an[0] ibias0 1.25652f
C281 m5_77252_13191r# m5_81602_13191# 0.08443f
C282 ota_cmfb_top_0.ota_cmfb_core_push_pull_output_stage_0/dynamic_pcell$4_0.DRN_NET_OP_GATE_MP vdd_1v2 0.01939f
C283 a_50396_27218# a_50660_27218# 0.02325f
C284 ota_cmfb_top_0.ota_cmfb_core_push_pull_output_stage_0/dynamic_pcell$4_0.B_DRN s5_an[2] 0.10479f
C285 a_50924_27218# a_51188_27218# 0.02325f
C286 ota_cmfb_top_0.ota_cmfb_core_push_pull_output_stage_0/dynamic_pcell$4_0.DRN_NET_J_GATE_EJ vdd_1v2 13.6845f
C287 ota_cmfb_top_0.dynamic_pcell$5_0.SRC_NET_KL ota_cmfb_top_0.dynamic_pcell$5_0.DRN_NET_JL 1.6724f
C288 a_51669_34440# a_51669_34240# 0.01257f
C289 ota_cmfb_top_0.dynamic_pcell$5_0.H_DRN ota_cmfb_top_0.dynamic_pcell$5_0.DRN_NET_CA 0.04573f
C290 m3_0_21663# analog_bus1 0.15943f
C291 ota_cmfb_top_0.ota_cmfb_core_push_pull_output_stage_1/dynamic_pcell$4_0.DRN_NET_OP_GATE_MP s5_an[1] 0.47083f
C292 ota_cmfb_top_0.dynamic_pcell$5_0.DRN_NET_JL ota_cmfb_top_0.dynamic_pcell$5_0.L_GATE 5.58516f
C293 enable a_51669_33631# 0.01214f
C294 s5_an[1] ota_cmfb_top_0.dynamic_pcell$5_0.DRN_NET_E_GATE_CDEFGH 0.01203f
C295 ota_cmfb_top_0.ota_cmfb_core_push_pull_output_stage_0/dynamic_pcell$4_0.SRC_NET_IJ_GATE_DI ota_cmfb_top_0.ota_cmfb_core_push_pull_output_stage_0/dynamic_pcell$4_0.B_DRN 1.72011f
C296 slot5_wrapper_0.dig_in[4] slot5_wrapper_0.dig_in[3] 0.23029f
C297 ota_cmfb_top_0.dynamic_pcell$5_0.DRN_NET_CA ota_cmfb_top_0.dynamic_pcell$5_0.DRN_NET_BD 5.97446f
C298 ota_cmfb_top_0.dynamic_pcell$5_0.F_DRN ota_cmfb_top_0.ota_cmfb_core_push_pull_output_stage_1/dynamic_pcell$4_0.DRN_NET_MENX 0.03843f
C299 a_58402_34440# a_58930_34440# 0.01672f
C300 enable ota_cmfb_top_0.dynamic_pcell$5_0.Gate 2.08928f
C301 ota_cmfb_top_0.ota_cmfb_core_push_pull_output_stage_1/EN_INV_0/sg13cmos5l_inv_4_0.Y ota_cmfb_top_0.ota_cmfb_core_push_pull_output_stage_1/dynamic_pcell$4_0.DRN_NET_MENX 0.09095f
C302 s5_an[2] a_58930_34440# 0.13315f
C303 ota_cmfb_top_0.dynamic_pcell$5_0.L_GATE a_48812_27132# 0.01108f
C304 enable ota_cmfb_top_0.EN_INV_0/sg13cmos5l_inv_4_0.Y 0.40609f
C305 s5_an[2] ota_cmfb_top_0.ota_cmfb_core_push_pull_output_stage_1/dynamic_pcell$4_0.DRN_NET_CD 0.01639f
C306 ibias0 enable 1.25501f
C307 a_58402_33917# a_58666_33917# 0.01702f
C308 s5_an[2] a_58930_33717# 0.01822f
C309 a_49604_27693# a_50132_27693# 0.01672f
C310 a_49868_27979# a_50132_27779# 0.01257f
C311 a_51669_33917# a_51933_33917# 0.01702f
C312 slot5_wrapper_0.dig_in[8] slot5_wrapper_0.dig_in[7] 0.23029f
C313 vdd_1v2 ota_cmfb_top_0.ota_cmfb_core_push_pull_output_stage_1/dynamic_pcell$4_0.DRN_NET_HI 2.75968f
C314 ota_cmfb_top_0.ota_cmfb_core_push_pull_output_stage_0/dynamic_pcell$4_0.DRN_NET_MENX ota_cmfb_top_0.ota_cmfb_core_push_pull_output_stage_0/EN_INV_0/sg13cmos5l_inv_4_0.Y 0.09161f
C315 a_50396_27979# a_50396_27779# 0.01257f
C316 analog_bus1 ota_cmfb_top_0.dynamic_pcell$5_0.H_DRN 0.0303f
C317 ota_cmfb_top_0.ota_cmfb_core_push_pull_output_stage_1/dynamic_pcell$4_0.DRN_NET_OP_GATE_MP ota_cmfb_top_0.ota_cmfb_core_push_pull_output_stage_1/dynamic_pcell$4_0.B_DRN 3.54939f
C318 ota_cmfb_top_0.ota_cmfb_core_push_pull_output_stage_0/EN_INV_0/sg13cmos5l_inv_4_0.Y ota_cmfb_top_0.dynamic_pcell$5_0.DRN_NET_BD 0.10465f
C319 a_49604_27693# a_49604_27418# 0.0607f
C320 a_50660_27693# a_50924_27779# 0.01257f
C321 ota_cmfb_top_0.dynamic_pcell$5_0.H_DRN ota_cmfb_top_0.dynamic_pcell$5_0.F_DRN 0.88459f
C322 slot5_wrapper_0.dig_in[12] slot5_wrapper_0.dig_in[11] 0.23029f
C323 vdd_1v2 ota_cmfb_top_0.ota_cmfb_core_push_pull_output_stage_1/dynamic_pcell$4_0.SRC_NET_IJ_GATE_DI 17.3226f
C324 a_49868_27979# a_49340_27979# 0.01672f
C325 a_48812_27218# a_48812_27132# 0.01257f
C326 a_50924_27132# enable 0.0122f
C327 ota_cmfb_top_0.ota_cmfb_core_push_pull_output_stage_0/dynamic_pcell$4_0.DRN_NET_MENX ota_cmfb_top_0.dynamic_pcell$5_0.F_DRN 0.14511f
C328 slot5_wrapper_0.vss_3v3 analog_bus1 0.01551f
C329 vdd_1v2 a_51188_27779# 0.01125f
C330 a_49076_27418# a_49604_27418# 0.01672f
C331 ota_cmfb_top_0.ota_cmfb_core_push_pull_output_stage_0/dynamic_pcell$4_0.DRN_NET_CD s5_an[2] 0.13443f
C332 analog_bus1 ota_cmfb_top_0.dynamic_pcell$5_0.DRN_NET_BD 8.88286f
C333 a_51933_33717# a_52197_33717# 0.02325f
C334 vdd_1v2 a_51933_33917# 0.0271f
C335 slot5_wrapper_0.dig_in[16] slot5_wrapper_0.dig_in[15] 0.23029f
C336 a_49604_27218# a_49868_27218# 0.02325f
C337 ota_cmfb_top_0.dynamic_pcell$5_0.DRN_NET_BD ota_cmfb_top_0.dynamic_pcell$5_0.F_DRN 10.2222f
C338 ota_cmfb_top_0.ota_cmfb_core_push_pull_output_stage_1/dynamic_pcell$4_0.Gate ota_cmfb_top_0.dynamic_pcell$5_0.DRN_NET_CA 0.04945f
C339 s5_an[0] enable 0.95173f
C340 slot5_wrapper_0.vss_3v3 m3_0_22839# 0.05f
C341 ota_cmfb_top_0.ota_cmfb_core_push_pull_output_stage_0/dynamic_pcell$4_0.DRN_NET_HI vdd_1v2 2.74927f
C342 slot5_wrapper_0.dig_in[20] slot5_wrapper_0.dig_in[19] 0.23029f
C343 analog_bus0 ota_cmfb_top_0.dynamic_pcell$5_0.H_DRN 0.11409f
C344 m5_2680_50438r# m5_7030_46988# 0.1335f
C345 ota_cmfb_top_0.ota_cmfb_core_push_pull_output_stage_0/dynamic_pcell$4_0.SRC_NET_IJ_GATE_DI ota_cmfb_top_0.ota_cmfb_core_push_pull_output_stage_0/dynamic_pcell$4_0.DRN_NET_CD 6.10437f
C346 a_50924_27132# s5_an[1] 0.01401f
C347 a_58402_34440# a_58402_34240# 0.01257f
C348 m3_0_19311# slot5_wrapper_0.vbias 0.15943f
C349 ota_cmfb_top_0.ota_cmfb_core_push_pull_output_stage_0/dynamic_pcell$4_0.DRN_NET_MENX ota_cmfb_top_0.ota_cmfb_core_push_pull_output_stage_0/dynamic_pcell$4_0.SRC_NET_ML 2.93895f
C350 analog_bus0 slot5_wrapper_0.vss_3v3 0.06022f
C351 w_59515_33612# a_59194_34240# 0.02344f
C352 a_50132_27218# a_49868_27132# 0.01257f
C353 analog_bus0 ota_cmfb_top_0.dynamic_pcell$5_0.DRN_NET_BD 4.17934f
C354 analog_bus1 ota_cmfb_top_0.dynamic_pcell$5_0.DRN_NET_CA 2.12718f
C355 a_58666_34240# a_58666_34154# 0.01257f
C356 a_51188_27218# vdd_1v2 0.01255f
C357 ota_cmfb_top_0.ota_cmfb_core_push_pull_output_stage_0/dynamic_pcell$4_0.SRC_NET_ML ota_cmfb_top_0.dynamic_pcell$5_0.DRN_NET_BD 0.02335f
C358 w_59515_33612# a_59194_33717# 0.01719f
C359 ota_cmfb_top_0.ota_cmfb_core_push_pull_output_stage_0/dynamic_pcell$4_0.Gate s5_an[2] 0.02992f
C360 ota_cmfb_top_0.ota_cmfb_core_push_pull_output_stage_1/dynamic_pcell$4_0.Gate ota_cmfb_top_0.dynamic_pcell$5_0.F_DRN 0.24081f
C361 ota_cmfb_top_0.ota_cmfb_core_push_pull_output_stage_1/EN_INV_0/sg13cmos5l_inv_4_0.Y ota_cmfb_top_0.ota_cmfb_core_push_pull_output_stage_1/dynamic_pcell$4_0.Gate 0.01391f
C362 ota_cmfb_top_0.ota_cmfb_core_push_pull_output_stage_1/EN_INV_0/sg13cmos5l_inv_4_0.Y ota_cmfb_top_0.dynamic_pcell$5_0.DRN_NET_CA 0.10465f
C363 ota_cmfb_top_0.dynamic_pcell$5_0.DRN_NET_CA ota_cmfb_top_0.dynamic_pcell$5_0.F_DRN 2.64069f
C364 s5_an[2] ota_cmfb_top_0.dynamic_pcell$5_0.G_DRN 0.35271f
C365 enable slot5_wrapper_0.reset 0.22207f
C366 a_58666_34154# a_58666_33917# 0.07379f
C367 a_58666_33917# a_58666_33717# 0.01257f
C368 s5_an[2] ota_cmfb_top_0.ota_cmfb_core_push_pull_output_stage_1/dynamic_pcell$4_0.DRN_NET_J_GATE_EJ 4.27287f
C369 w_52782_33612# a_51933_34154# 0.01701f
C370 m5_72902_13191# m5_77252_13191r# 0.3738f
C371 vdd_1v2 ota_cmfb_top_0.ota_cmfb_core_push_pull_output_stage_1/dynamic_pcell$4_0.DRN_NET_MENX 3.23606f
C372 ota_cmfb_top_0.ota_cmfb_core_push_pull_output_stage_0/EN_INV_0/sg13cmos5l_inv_4_0.Y ota_cmfb_top_0.dynamic_pcell$5_0.F_DRN 0.03524f
C373 a_50396_27218# a_50396_27132# 0.01257f
C374 ota_cmfb_top_0.ota_cmfb_core_push_pull_output_stage_0/dynamic_pcell$4_0.SRC_NET_IJ_GATE_DI ota_cmfb_top_0.ota_cmfb_core_push_pull_output_stage_0/dynamic_pcell$4_0.Gate 0.02434f
C375 ota_cmfb_top_0.dynamic_pcell$5_0.H_DRN ota_cmfb_top_0.dynamic_pcell$5_0.SRC_NET_AB 0.1765f
C376 ota_cmfb_top_0.ota_cmfb_core_push_pull_output_stage_1/dynamic_pcell$4_0.DRN_NET_OP_GATE_MP ota_cmfb_top_0.ota_cmfb_core_push_pull_output_stage_1/dynamic_pcell$4_0.SRC_NET_ML 2.78684f
C377 ota_cmfb_top_0.ota_cmfb_core_push_pull_output_stage_0/dynamic_pcell$4_0.DRN_NET_OP_GATE_MP s5_an[2] 0.46756f
C378 analog_bus0 ota_cmfb_top_0.dynamic_pcell$5_0.DRN_NET_CA 8.78099f
C379 ota_cmfb_top_0.dynamic_pcell$5_0.DRN_NET_JL ota_cmfb_top_0.dynamic_pcell$5_0.DRN_NET_E_GATE_CDEFGH 0.25247f
C380 w_52782_33612# ota_cmfb_top_0.dynamic_pcell$5_0.DRN_NET_CA 9.51334f
C381 enable s5_an[1] 2.79349f
C382 vdd_1v2 ota_cmfb_top_0.dynamic_pcell$5_0.H_DRN 32.6147f
C383 ota_cmfb_top_0.ota_cmfb_core_push_pull_output_stage_1/EN_INV_0/sg13cmos5l_inv_4_0.Y ota_cmfb_top_0.dynamic_pcell$5_0.F_DRN 0.03345f
C384 ota_cmfb_top_0.dynamic_pcell$5_0.DRN_NET_BD ota_cmfb_top_0.dynamic_pcell$5_0.SRC_NET_AB 2.50866f
C385 ota_cmfb_top_0.ota_cmfb_core_push_pull_output_stage_0/dynamic_pcell$4_0.DRN_NET_J_GATE_EJ s5_an[2] 0.02831f
C386 a_51669_33917# a_51933_34154# 0.0169f
C387 ota_cmfb_top_0.ota_cmfb_core_push_pull_output_stage_0/dynamic_pcell$4_0.DRN_NET_MENX vdd_1v2 3.21138f
C388 a_52197_34240# a_52461_34240# 0.02325f
C389 a_58402_34440# a_58666_34240# 0.01257f
C390 s5_an[2] a_58666_34240# 0.01419f
C391 ota_cmfb_top_0.ota_cmfb_core_push_pull_output_stage_0/EN_INV_0/sg13cmos5l_inv_4_0.Y ota_cmfb_top_0.ota_cmfb_core_push_pull_output_stage_0/dynamic_pcell$4_0.SRC_NET_ML 0.02102f
C392 vdd_1v2 ota_cmfb_top_0.dynamic_pcell$5_0.DRN_NET_BD 13.4469f
C393 a_58402_33917# a_58402_33717# 0.01242f
C394 s5_an[2] a_58666_33917# 0.12904f
C395 a_49604_27693# a_49868_27779# 0.01257f
C396 a_51669_33917# a_51669_33717# 0.01242f
C397 analog_bus0 analog_bus1 8.36971f
C398 ota_cmfb_top_0.ota_cmfb_core_push_pull_output_stage_0/dynamic_pcell$4_0.SRC_NET_IJ_GATE_DI ota_cmfb_top_0.ota_cmfb_core_push_pull_output_stage_0/dynamic_pcell$4_0.DRN_NET_J_GATE_EJ 5.83794f
C399 a_50132_27779# a_50396_27779# 0.02325f
C400 vdd_1v2 a_51933_34154# 0.02315f
C401 enable ota_cmfb_top_0.ota_cmfb_core_push_pull_output_stage_1/dynamic_pcell$4_0.B_DRN 0.50395f
C402 analog_bus0 m3_0_22839# 0.15943f
C403 ota_cmfb_top_0.ota_cmfb_core_push_pull_output_stage_0/dynamic_pcell$4_0.SRC_NET_ML ota_cmfb_top_0.dynamic_pcell$5_0.F_DRN 0.53557f
C404 ota_cmfb_top_0.dynamic_pcell$5_0.DRN_NET_JL a_49340_27979# 0.0104f
C405 s5_an[2] ota_cmfb_top_0.ota_cmfb_core_push_pull_output_stage_1/dynamic_pcell$4_0.DRN_NET_HI 0.01984f
C406 slot5_wrapper_0.dig_out[4] slot5_wrapper_0.dig_out[3] 0.23029f
C407 a_49604_27693# a_49076_27693# 0.01672f
C408 ota_cmfb_top_0.dynamic_pcell$5_0.DRN_NET_CA ota_cmfb_top_0.dynamic_pcell$5_0.SRC_NET_AB 0.73788f
C409 ota_cmfb_top_0.dynamic_pcell$5_0.DRN_NET_JL ota_cmfb_top_0.dynamic_pcell$5_0.Gate 5.76497f
C410 s5_an[1] a_52461_33717# 0.02652f
C411 ota_cmfb_top_0.dynamic_pcell$5_0.DRN_NET_JL ota_cmfb_top_0.EN_INV_0/sg13cmos5l_inv_4_0.Y 0.0296f
C412 ota_cmfb_top_0.ota_cmfb_core_push_pull_output_stage_1/dynamic_pcell$4_0.DRN_NET_OP_GATE_MP ota_cmfb_top_0.dynamic_pcell$5_0.G_DRN 0.02905f
C413 vdd_1v2 a_50924_27979# 0.06808f
C414 a_49076_27418# a_49340_27218# 0.01257f
C415 a_48812_27132# a_49340_27132# 0.01672f
C416 ota_cmfb_top_0.dynamic_pcell$5_0.G_DRN ota_cmfb_top_0.dynamic_pcell$5_0.DRN_NET_E_GATE_CDEFGH 9.14611f
C417 a_51933_33917# a_51933_33717# 0.01257f
C418 vdd_1v2 a_51669_33717# 0.01689f
C419 s5_an[2] ota_cmfb_top_0.ota_cmfb_core_push_pull_output_stage_1/dynamic_pcell$4_0.SRC_NET_IJ_GATE_DI 0.13867f
C420 a_49076_27418# a_49076_27693# 0.0607f
C421 ota_cmfb_top_0.ota_cmfb_core_push_pull_output_stage_1/dynamic_pcell$4_0.DRN_NET_OP_GATE_MP ota_cmfb_top_0.ota_cmfb_core_push_pull_output_stage_1/dynamic_pcell$4_0.DRN_NET_J_GATE_EJ 0.28979f
C422 slot5_wrapper_0.dig_out[8] slot5_wrapper_0.dig_out[7] 0.23029f
C423 a_49604_27418# a_49604_27218# 0.01257f
C424 ota_cmfb_top_0.ota_cmfb_core_push_pull_output_stage_1/dynamic_pcell$4_0.Gate vdd_1v2 0.04919f
C425 vdd_1v2 ota_cmfb_top_0.dynamic_pcell$5_0.DRN_NET_CA 11.1326f
C426 slot5_wrapper_0.analog_bus3 m3_0_20487# 0.15943f
C427 s5_an[2] a_51188_27779# 0.02039f
C428 ota_cmfb_top_0.ota_cmfb_core_push_pull_output_stage_0/dynamic_pcell$4_0.B_DRN enable 0.34233f
C429 a_49340_27779# a_49604_27779# 0.02325f
C430 a_48812_27979# a_48812_27779# 0.01257f
C431 s5_an[1] ota_cmfb_top_0.ota_cmfb_core_push_pull_output_stage_1/dynamic_pcell$4_0.B_DRN 0.13311f
C432 vdd_1v2 a_48812_27979# 0.05592f
C433 slot5_wrapper_0.dig_in[0] slot5_wrapper_0.dig_out[11] 0.05407f
C434 ota_cmfb_top_0.dynamic_pcell$5_0.DRN_NET_CA a_58402_33917# 0.01179f
C435 analog_bus1 ota_cmfb_top_0.dynamic_pcell$5_0.SRC_NET_AB 2.73939f
C436 ota_cmfb_top_0.ota_cmfb_core_push_pull_output_stage_0/EN_INV_0/sg13cmos5l_inv_4_0.Y vdd_1v2 0.42327f
C437 s5_an[0] ota_cmfb_top_0.dynamic_pcell$5_0.DRN_NET_JL 0.04861f
C438 w_59515_33612# a_58930_34440# 0.01802f
C439 vdd_1v2 analog_bus1 16.0073f
C440 ota_cmfb_top_0.dynamic_pcell$5_0.Gate ota_cmfb_top_0.dynamic_pcell$5_0.G_DRN 0.04911f
C441 ota_cmfb_top_0.ota_cmfb_core_push_pull_output_stage_0/dynamic_pcell$4_0.SRC_NET_IJ_GATE_DI ota_cmfb_top_0.ota_cmfb_core_push_pull_output_stage_0/dynamic_pcell$4_0.DRN_NET_HI 3.72801f
C442 ota_cmfb_top_0.dynamic_pcell$5_0.H_DRN ota_cmfb_top_0.dynamic_pcell$5_0.SRC_NET_KL 8.30578f
C443 ota_cmfb_top_0.ota_cmfb_core_push_pull_output_stage_0/dynamic_pcell$4_0.B_DRN s5_an[1] 0.03476f
C444 ota_cmfb_top_0.ota_cmfb_core_push_pull_output_stage_1/EN_INV_0/sg13cmos5l_inv_4_0.Y vdd_1v2 0.42641f
C445 a_58930_34440# a_59194_34240# 0.01257f
C446 vdd_1v2 ota_cmfb_top_0.dynamic_pcell$5_0.F_DRN 52.1725f
C447 enable ota_cmfb_top_0.ota_cmfb_core_push_pull_output_stage_1/dynamic_pcell$4_0.DRN_NET_CD 0.02557f
C448 a_58402_33717# a_58666_33717# 0.02325f
C449 ota_cmfb_top_0.dynamic_pcell$5_0.H_DRN ota_cmfb_top_0.dynamic_pcell$5_0.L_GATE 0.10515f
C450 a_58930_33717# a_59194_33717# 0.02325f
C451 ota_cmfb_top_0.dynamic_pcell$5_0.SRC_NET_KL ota_cmfb_top_0.dynamic_pcell$5_0.DRN_NET_BD 0.03997f
C452 m5_68552_16641r# m5_72902_13191# 0.1335f
C453 analog_bus0 ota_cmfb_top_0.dynamic_pcell$5_0.SRC_NET_AB 2.35414f
C454 a_50132_27218# a_50396_27218# 0.02325f
C455 slot5_wrapper_0.dig_in[5] slot5_wrapper_0.dig_in[4] 0.23029f
C456 ota_cmfb_top_0.dynamic_pcell$5_0.DRN_NET_BD ota_cmfb_top_0.dynamic_pcell$5_0.L_GATE 0.06608f
C457 a_50660_27418# a_50924_27218# 0.01257f
C458 a_50396_27132# a_50924_27132# 0.01672f
C459 enable ota_cmfb_top_0.dynamic_pcell$5_0.DRN_NET_JL 0.20784f
C460 s5_an[2] ota_cmfb_top_0.ota_cmfb_core_push_pull_output_stage_1/dynamic_pcell$4_0.DRN_NET_MENX 0.08199f
C461 ota_cmfb_top_0.ota_cmfb_core_push_pull_output_stage_0/dynamic_pcell$4_0.DRN_NET_CD enable 0.02297f
C462 analog_bus0 vdd_1v2 15.971f
C463 slot5_wrapper_0.dig_in[9] slot5_wrapper_0.dig_in[8] 0.23029f
C464 w_52782_33612# a_52197_33631# 0.01194f
C465 s5_an[1] ota_cmfb_top_0.ota_cmfb_core_push_pull_output_stage_1/dynamic_pcell$4_0.DRN_NET_CD 0.13538f
C466 vdd_1v2 w_52782_33612# 2.27694f
C467 a_51669_34240# a_51933_34240# 0.02325f
C468 a_52197_34440# a_52197_34240# 0.01257f
C469 slot5_wrapper_0.dig_in[13] slot5_wrapper_0.dig_in[12] 0.23029f
C470 m3_0_21663# slot5_wrapper_0.analog_bus2 0.15943f
C471 ibias0 m3_0_19311# 0.15943f
C472 vdd_1v2 a_58930_33631# 0.03233f
C473 ota_cmfb_top_0.dynamic_pcell$5_0.SRC_NET_KL ota_cmfb_top_0.dynamic_pcell$5_0.DRN_NET_CA 0.05257f
C474 ota_cmfb_top_0.ota_cmfb_core_push_pull_output_stage_1/dynamic_pcell$4_0.SRC_NET_ML s5_an[1] 0.07621f
C475 ota_cmfb_top_0.ota_cmfb_core_push_pull_output_stage_0/dynamic_pcell$4_0.DRN_NET_MENX s5_an[2] 0.19927f
C476 m5_22930_46988# m5_18580_46988# 0.534f
C477 slot5_wrapper_0.dig_in[17] slot5_wrapper_0.dig_in[16] 0.23029f
C478 ota_cmfb_top_0.dynamic_pcell$5_0.DRN_NET_CA ota_cmfb_top_0.dynamic_pcell$5_0.L_GATE 3.24676f
C479 ota_cmfb_top_0.dynamic_pcell$5_0.L_GATE a_49076_27693# 0.01688f
C480 s5_an[2] ota_cmfb_top_0.dynamic_pcell$5_0.DRN_NET_BD 1.45341f
C481 a_50132_27779# a_50132_27693# 0.01257f
C482 vdd_1v2 a_51669_33917# 0.05833f
C483 ota_cmfb_top_0.ota_cmfb_core_push_pull_output_stage_1/dynamic_pcell$4_0.B_DRN ota_cmfb_top_0.ota_cmfb_core_push_pull_output_stage_1/dynamic_pcell$4_0.DRN_NET_CD 0.03703f
C484 a_50396_27979# a_50924_27979# 0.01672f
C485 a_52461_34240# ota_cmfb_top_0.dynamic_pcell$5_0.DRN_NET_CA 0.01075f
C486 ota_cmfb_top_0.dynamic_pcell$5_0.L_GATE a_48812_27979# 0.01114f
C487 slot5_wrapper_0.dig_in[21] slot5_wrapper_0.dig_in[20] 0.23029f
C488 a_50924_27779# a_51188_27779# 0.02325f
C489 enable ota_cmfb_top_0.dynamic_pcell$5_0.G_DRN 0.46065f
C490 vdd_1v2 ota_cmfb_top_0.dynamic_pcell$5_0.SRC_NET_AB 5.96391f
C491 a_49868_27779# a_49604_27779# 0.02325f
C492 ota_cmfb_top_0.ota_cmfb_core_push_pull_output_stage_0/dynamic_pcell$4_0.SRC_NET_IJ_GATE_DI ota_cmfb_top_0.ota_cmfb_core_push_pull_output_stage_0/dynamic_pcell$4_0.DRN_NET_MENX 0.13717f
C493 a_48812_27132# a_49076_27218# 0.01257f
C494 a_51669_33717# a_51933_33717# 0.02325f
C495 enable ota_cmfb_top_0.ota_cmfb_core_push_pull_output_stage_1/dynamic_pcell$4_0.DRN_NET_J_GATE_EJ 0.03636f
C496 analog_bus1 ota_cmfb_top_0.dynamic_pcell$5_0.SRC_NET_KL 1.55605f
C497 ota_cmfb_top_0.ota_cmfb_core_push_pull_output_stage_1/dynamic_pcell$4_0.SRC_NET_ML ota_cmfb_top_0.ota_cmfb_core_push_pull_output_stage_1/dynamic_pcell$4_0.B_DRN 0.42237f
C498 a_49340_27218# a_49604_27218# 0.02325f
C499 ota_cmfb_top_0.ota_cmfb_core_push_pull_output_stage_0/dynamic_pcell$4_0.SRC_NET_IJ_GATE_DI ota_cmfb_top_0.dynamic_pcell$5_0.DRN_NET_BD 3.99589f
C500 a_52197_33717# a_52461_33717# 0.02325f
C501 vdd_1v2 a_52197_33631# 0.05104f
C502 s5_an[2] a_50924_27979# 0.01389f
C503 analog_bus1 ota_cmfb_top_0.dynamic_pcell$5_0.L_GATE 0.1169f
C504 a_49340_27979# a_49340_27779# 0.01257f
C505 s5_an[2] ota_cmfb_top_0.dynamic_pcell$5_0.DRN_NET_CA 0.1023f
C506 vdd_1v2 a_58402_33917# 0.02884f
C507 ota_cmfb_top_0.ota_cmfb_core_push_pull_output_stage_1/dynamic_pcell$4_0.DRN_NET_OP_GATE_MP ota_cmfb_top_0.ota_cmfb_core_push_pull_output_stage_1/dynamic_pcell$4_0.DRN_NET_MENX 5.62824f
C508 ota_cmfb_top_0.ota_cmfb_core_push_pull_output_stage_0/dynamic_pcell$4_0.Gate s5_an[1] 0.02841f
C509 s5_an[1] ota_cmfb_top_0.dynamic_pcell$5_0.G_DRN 0.69845f
C510 slot5_wrapper_0.dig_in[2] slot5_wrapper_0.dig_in[3] 0.23029f
C511 slot5_wrapper_0.ibias1 m3_0_19899# 0.15943f
C512 s5_an[1] ota_cmfb_top_0.ota_cmfb_core_push_pull_output_stage_1/dynamic_pcell$4_0.DRN_NET_J_GATE_EJ 0.07944f
C513 analog_bus0 ota_cmfb_top_0.dynamic_pcell$5_0.SRC_NET_KL 1.69102f
C514 ota_cmfb_top_0.ota_cmfb_core_push_pull_output_stage_0/dynamic_pcell$4_0.B_DRN ota_cmfb_top_0.ota_cmfb_core_push_pull_output_stage_0/dynamic_pcell$4_0.DRN_NET_CD 0.03703f
C515 a_58666_34154# a_58930_34240# 0.01257f
C516 analog_bus0 ota_cmfb_top_0.dynamic_pcell$5_0.L_GATE 0.17143f
C517 ota_cmfb_top_0.dynamic_pcell$5_0.H_DRN ota_cmfb_top_0.dynamic_pcell$5_0.DRN_NET_E_GATE_CDEFGH 2.75925f
C518 a_58402_33717# a_58402_33631# 0.01257f
C519 s5_an[2] ota_cmfb_top_0.dynamic_pcell$5_0.F_DRN 0.33518f
C520 ota_cmfb_top_0.dynamic_pcell$5_0.G_DRN ota_cmfb_top_0.ota_cmfb_core_push_pull_output_stage_1/dynamic_pcell$4_0.B_DRN 5.94931f
C521 w_52782_33612# a_52461_34240# 0.02344f
C522 vdd_1v2 ota_cmfb_top_0.EN_INV_1/sg13cmos5l_inv_4_0.Y 0.45533f
C523 ota_cmfb_top_0.ota_cmfb_core_push_pull_output_stage_0/dynamic_pcell$4_0.DRN_NET_J_GATE_EJ s5_an[1] 0.05904f
C524 ota_cmfb_top_0.dynamic_pcell$5_0.DRN_NET_BD ota_cmfb_top_0.dynamic_pcell$5_0.DRN_NET_E_GATE_CDEFGH 12.1403f
C525 ota_cmfb_top_0.ota_cmfb_core_push_pull_output_stage_1/dynamic_pcell$4_0.B_DRN ota_cmfb_top_0.ota_cmfb_core_push_pull_output_stage_1/dynamic_pcell$4_0.DRN_NET_J_GATE_EJ 1.48218f
C526 a_50396_27132# a_50660_27218# 0.01257f
C527 m5_93152_13941r# m5_97502_13341r# 0.2403f
C528 a_50924_27132# a_51188_27218# 0.01257f
C529 enable ota_cmfb_top_0.ota_cmfb_core_push_pull_output_stage_1/dynamic_pcell$4_0.SRC_NET_IJ_GATE_DI 0.11166f
C530 slot5_wrapper_0.dig_out[1] slot5_wrapper_0.dig_out[0] 0.23029f
C531 ota_cmfb_top_0.ota_cmfb_core_push_pull_output_stage_0/dynamic_pcell$4_0.SRC_NET_IJ_GATE_DI ota_cmfb_top_0.dynamic_pcell$5_0.F_DRN 2.33609f
C532 ota_cmfb_top_0.ota_cmfb_core_push_pull_output_stage_0/dynamic_pcell$4_0.B_DRN ota_cmfb_top_0.ota_cmfb_core_push_pull_output_stage_0/dynamic_pcell$4_0.Gate 0.76295f
C533 ota_cmfb_top_0.dynamic_pcell$5_0.SRC_NET_KL ota_cmfb_top_0.dynamic_pcell$5_0.SRC_NET_AB 1.33403f
C534 ota_cmfb_top_0.dynamic_pcell$5_0.H_DRN ota_cmfb_top_0.dynamic_pcell$5_0.Gate 0.17821f
C535 a_51933_34240# a_52197_34240# 0.02325f
C536 ota_cmfb_top_0.ota_cmfb_core_push_pull_output_stage_0/dynamic_pcell$4_0.SRC_NET_ML s5_an[2] 0.0758f
C537 slot5_wrapper_0.dig_out[5] slot5_wrapper_0.dig_out[4] 0.23029f
C538 ota_cmfb_top_0.dynamic_pcell$5_0.L_GATE ota_cmfb_top_0.dynamic_pcell$5_0.SRC_NET_AB 0.17789f
C539 ota_cmfb_top_0.ota_cmfb_core_push_pull_output_stage_1/dynamic_pcell$4_0.Gate ota_cmfb_top_0.ota_cmfb_core_push_pull_output_stage_1/dynamic_pcell$4_0.DRN_NET_OP_GATE_MP 6.18805f
C540 ota_cmfb_top_0.ota_cmfb_core_push_pull_output_stage_1/dynamic_pcell$4_0.DRN_NET_OP_GATE_MP ota_cmfb_top_0.dynamic_pcell$5_0.DRN_NET_CA 0.04023f
C541 vdd_1v2 ota_cmfb_top_0.dynamic_pcell$5_0.SRC_NET_KL 6.572f
C542 a_58402_33917# a_58666_34154# 0.0169f
C543 ota_cmfb_top_0.dynamic_pcell$5_0.DRN_NET_CA ota_cmfb_top_0.dynamic_pcell$5_0.DRN_NET_E_GATE_CDEFGH 11.487f
C544 s5_an[2] a_58930_34240# 0.01822f
C545 ota_cmfb_top_0.dynamic_pcell$5_0.L_GATE a_49076_27418# 0.01688f
C546 slot5_wrapper_0.dig_out[9] slot5_wrapper_0.dig_out[8] 0.23029f
C547 ota_cmfb_top_0.dynamic_pcell$5_0.DRN_NET_BD ota_cmfb_top_0.dynamic_pcell$5_0.Gate 1.09377f
C548 s5_an[2] a_58930_33631# 0.14737f
C549 a_49868_27779# a_50132_27779# 0.02325f
C550 ota_cmfb_top_0.dynamic_pcell$5_0.L_GATE a_48812_27779# 0.0169f
C551 vdd_1v2 ota_cmfb_top_0.dynamic_pcell$5_0.L_GATE 4.40184f
C552 vdd_1v2 a_51669_34440# 0.04008f
C553 s5_an[1] ota_cmfb_top_0.ota_cmfb_core_push_pull_output_stage_1/dynamic_pcell$4_0.SRC_NET_IJ_GATE_DI 0.1869f
C554 a_50132_27693# a_50660_27693# 0.01672f
C555 a_50396_27979# a_50660_27779# 0.01257f
C556 ota_cmfb_top_0.ota_cmfb_core_push_pull_output_stage_0/dynamic_pcell$4_0.B_DRN ota_cmfb_top_0.ota_cmfb_core_push_pull_output_stage_0/dynamic_pcell$4_0.DRN_NET_OP_GATE_MP 3.54939f
C557 slot5_wrapper_0.dig_in[1] slot5_wrapper_0.dig_in[0] 0.23029f
C558 a_50924_27979# a_50924_27779# 0.01257f
C559 ota_cmfb_top_0.dynamic_pcell$5_0.G_DRN ota_cmfb_top_0.ota_cmfb_core_push_pull_output_stage_1/dynamic_pcell$4_0.DRN_NET_CD 3.4607f
C560 s5_an[1] a_51933_33917# 0.02303f
C561 a_49604_27693# a_49604_27779# 0.01257f
C562 ota_cmfb_top_0.ota_cmfb_core_push_pull_output_stage_0/dynamic_pcell$4_0.B_DRN ota_cmfb_top_0.ota_cmfb_core_push_pull_output_stage_0/dynamic_pcell$4_0.DRN_NET_J_GATE_EJ 1.48907f
C563 vdd_1v2 a_50396_27979# 0.06157f
C564 a_50132_27693# a_50132_27418# 0.0607f
C565 s5_an[0] ota_cmfb_top_0.dynamic_pcell$5_0.H_DRN 0.35977f
C566 a_51669_33717# a_51669_33631# 0.01257f
C567 ota_cmfb_top_0.ota_cmfb_core_push_pull_output_stage_1/dynamic_pcell$4_0.B_DRN ota_cmfb_top_0.ota_cmfb_core_push_pull_output_stage_1/dynamic_pcell$4_0.DRN_NET_HI 0.03502f
C568 ota_cmfb_top_0.ota_cmfb_core_push_pull_output_stage_1/dynamic_pcell$4_0.DRN_NET_CD ota_cmfb_top_0.ota_cmfb_core_push_pull_output_stage_1/dynamic_pcell$4_0.DRN_NET_J_GATE_EJ 0.07255f
R0 enable enable.n9 88.2888
R1 enable.n9 enable.t2 66.6582
R2 enable.n1 enable.t11 45.242
R3 enable.n1 enable.t10 43.3729
R4 enable.n2 enable.t6 42.9825
R5 enable.n0 enable.t9 42.4471
R6 enable.n3 enable.t8 42.4471
R7 enable.n2 enable.t7 42.4141
R8 enable.n4 enable.t0 37.6627
R9 enable.n0 enable.n2 32.3868
R10 enable.n5 enable.n4 25.2664
R11 enable.n6 enable.t3 22.8817
R12 enable.n4 enable.t1 22.8497
R13 enable.n8 enable.n7 18.9928
R14 enable.n6 enable.n5 17.7329
R15 enable.n5 enable.n3 11.455
R16 enable.n9 enable.n8 11.3773
R17 enable.n7 enable.t5 4.82498
R18 enable.n7 enable.t4 3.888
R19 enable.n8 enable.n6 3.20059
R20 enable.n3 enable.n0 1.41988
R21 enable.n0 enable.n1 1.31079
R22 vdd_1v2.n332 vdd_1v2.t25 35.4308
R23 vdd_1v2.n333 vdd_1v2.t27 35.4308
R24 vdd_1v2.n334 vdd_1v2.t29 35.4308
R25 vdd_1v2.n335 vdd_1v2.t31 35.4308
R26 vdd_1v2.n489 vdd_1v2.t468 35.4308
R27 vdd_1v2.n488 vdd_1v2.t466 35.4308
R28 vdd_1v2.n487 vdd_1v2.t464 35.4308
R29 vdd_1v2.n486 vdd_1v2.t462 35.4308
R30 vdd_1v2.n241 vdd_1v2.n240 27.7104
R31 vdd_1v2.n79 vdd_1v2.t104 24.524
R32 vdd_1v2.n79 vdd_1v2.t458 19.7896
R33 vdd_1v2.n80 vdd_1v2.t23 19.7896
R34 vdd_1v2.n410 vdd_1v2.t19 19.5021
R35 vdd_1v2.n613 vdd_1v2.t441 19.5021
R36 vdd_1v2.n336 vdd_1v2.n335 19.3912
R37 vdd_1v2.n486 vdd_1v2.n485 19.3912
R38 vdd_1v2.n332 vdd_1v2.n331 19.3912
R39 vdd_1v2.n490 vdd_1v2.n489 19.3912
R40 vdd_1v2.n406 vdd_1v2.t9 18.3757
R41 vdd_1v2.n609 vdd_1v2.t443 18.3757
R42 vdd_1v2.n402 vdd_1v2.t8 17.7685
R43 vdd_1v2.n605 vdd_1v2.t435 17.7685
R44 vdd_1v2.t0 vdd_1v2.t405 17.433
R45 vdd_1v2.t0 vdd_1v2.t400 17.8785
R46 vdd_1v2.t0 vdd_1v2.t408 17.5987
R47 vdd_1v2.n405 vdd_1v2.n401 17.144
R48 vdd_1v2.n608 vdd_1v2.n604 17.144
R49 vdd_1v2.n344 vdd_1v2.t193 17.0005
R50 vdd_1v2.n38 vdd_1v2.t195 17.0005
R51 vdd_1v2.n339 vdd_1v2.t182 17.0005
R52 vdd_1v2.n315 vdd_1v2.t184 17.0005
R53 vdd_1v2.n313 vdd_1v2.t186 17.0005
R54 vdd_1v2.n341 vdd_1v2.t188 17.0005
R55 vdd_1v2.n311 vdd_1v2.t190 17.0005
R56 vdd_1v2.n336 vdd_1v2.t33 17.0005
R57 vdd_1v2.n337 vdd_1v2.t179 17.0005
R58 vdd_1v2.n338 vdd_1v2.t178 17.0005
R59 vdd_1v2.n329 vdd_1v2.t158 17.0005
R60 vdd_1v2.n330 vdd_1v2.t176 17.0005
R61 vdd_1v2.n331 vdd_1v2.t24 17.0005
R62 vdd_1v2.n324 vdd_1v2.t166 17.0005
R63 vdd_1v2.n321 vdd_1v2.t168 17.0005
R64 vdd_1v2.n319 vdd_1v2.t170 17.0005
R65 vdd_1v2.n326 vdd_1v2.t172 17.0005
R66 vdd_1v2.n317 vdd_1v2.t157 17.0005
R67 vdd_1v2.t0 vdd_1v2.t155 17.0005
R68 vdd_1v2.n323 vdd_1v2.t154 17.0005
R69 vdd_1v2.t0 vdd_1v2.n50 1.03236
R70 vdd_1v2.n58 vdd_1v2.n53 0.145051
R71 vdd_1v2.n476 vdd_1v2.t245 17.0005
R72 vdd_1v2.n477 vdd_1v2.t244 17.0005
R73 vdd_1v2.n478 vdd_1v2.t66 17.0005
R74 vdd_1v2.n474 vdd_1v2.t65 17.0005
R75 vdd_1v2.n472 vdd_1v2.t249 17.0005
R76 vdd_1v2.n480 vdd_1v2.t251 17.0005
R77 vdd_1v2.n470 vdd_1v2.t253 17.0005
R78 vdd_1v2.n483 vdd_1v2.t255 17.0005
R79 vdd_1v2.n484 vdd_1v2.t257 17.0005
R80 vdd_1v2.n485 vdd_1v2.t461 17.0005
R81 vdd_1v2.n490 vdd_1v2.t470 17.0005
R82 vdd_1v2.n491 vdd_1v2.t260 17.0005
R83 vdd_1v2.n492 vdd_1v2.t259 17.0005
R84 vdd_1v2.n493 vdd_1v2.t262 17.0005
R85 vdd_1v2.n468 vdd_1v2.t264 17.0005
R86 vdd_1v2.n466 vdd_1v2.t266 17.0005
R87 vdd_1v2.n495 vdd_1v2.t268 17.0005
R88 vdd_1v2.n464 vdd_1v2.t270 17.0005
R89 vdd_1v2.n2 vdd_1v2.t272 17.0005
R90 vdd_1v2.t0 vdd_1v2.t274 17.0005
R91 vdd_1v2.t222 vdd_1v2.n243 15.625
R92 vdd_1v2.t36 vdd_1v2.n279 15.625
R93 vdd_1v2.n407 vdd_1v2.t17 15.4013
R94 vdd_1v2.n406 vdd_1v2.t14 15.4013
R95 vdd_1v2.n610 vdd_1v2.t449 15.4013
R96 vdd_1v2.n609 vdd_1v2.t447 15.4013
R97 vdd_1v2.t199 vdd_1v2.n47 15.1981
R98 vdd_1v2.t394 vdd_1v2.n436 15.1618
R99 vdd_1v2.n438 vdd_1v2.t394 15.1618
R100 vdd_1v2.t351 vdd_1v2.n519 15.1618
R101 vdd_1v2.t282 vdd_1v2.n512 15.1618
R102 vdd_1v2.n515 vdd_1v2.t282 15.1618
R103 vdd_1v2.n300 vdd_1v2.t146 15.1618
R104 vdd_1v2.t146 vdd_1v2.n297 15.1618
R105 vdd_1v2.n162 vdd_1v2.t234 15.1618
R106 vdd_1v2.t234 vdd_1v2.n161 15.1618
R107 vdd_1v2.n282 vdd_1v2.t36 15.1618
R108 vdd_1v2.n247 vdd_1v2.t222 15.1618
R109 vdd_1v2.t131 vdd_1v2.n272 15.1618
R110 vdd_1v2.n275 vdd_1v2.t131 15.1618
R111 vdd_1v2.n179 vdd_1v2.t210 15.1618
R112 vdd_1v2.t210 vdd_1v2.n178 15.1618
R113 vdd_1v2.n268 vdd_1v2.t133 15.1618
R114 vdd_1v2.t133 vdd_1v2.n265 15.1618
R115 vdd_1v2.n286 vdd_1v2.t199 15.1618
R116 vdd_1v2.n95 vdd_1v2.t111 15.1618
R117 vdd_1v2.t111 vdd_1v2.n93 15.1618
R118 vdd_1v2.n306 vdd_1v2.t159 15.1618
R119 vdd_1v2.t159 vdd_1v2.n305 15.1618
R120 vdd_1v2.t144 vdd_1v2.n290 15.1618
R121 vdd_1v2.n292 vdd_1v2.t144 15.1618
R122 vdd_1v2.n253 vdd_1v2.t140 15.1618
R123 vdd_1v2.t140 vdd_1v2.n252 15.1618
R124 vdd_1v2.n260 vdd_1v2.t34 15.1618
R125 vdd_1v2.t34 vdd_1v2.n259 15.1618
R126 vdd_1v2.t213 vdd_1v2.n170 15.1618
R127 vdd_1v2.n173 vdd_1v2.t213 15.1618
R128 vdd_1v2.t225 vdd_1v2.n167 15.1618
R129 vdd_1v2.n1 vdd_1v2.t225 15.1618
R130 vdd_1v2.t237 vdd_1v2.n153 15.1618
R131 vdd_1v2.n156 vdd_1v2.t237 15.1618
R132 vdd_1v2.t343 vdd_1v2.n443 15.1618
R133 vdd_1v2.n445 vdd_1v2.t343 15.1618
R134 vdd_1v2.t319 vdd_1v2.n374 15.1618
R135 vdd_1v2.n376 vdd_1v2.t319 15.1618
R136 vdd_1v2.n369 vdd_1v2.t311 15.1618
R137 vdd_1v2.t311 vdd_1v2.n368 15.1618
R138 vdd_1v2.n362 vdd_1v2.t299 15.1618
R139 vdd_1v2.t299 vdd_1v2.n361 15.1618
R140 vdd_1v2.n348 vdd_1v2.t289 15.1618
R141 vdd_1v2.t289 vdd_1v2.n347 15.1618
R142 vdd_1v2.t278 vdd_1v2.n353 15.1618
R143 vdd_1v2.n355 vdd_1v2.t278 15.1618
R144 vdd_1v2.n521 vdd_1v2.t351 15.1618
R145 vdd_1v2.t357 vdd_1v2.n499 15.1618
R146 vdd_1v2.n504 vdd_1v2.t297 15.1618
R147 vdd_1v2.t297 vdd_1v2.n502 15.1618
R148 vdd_1v2.n501 vdd_1v2.t357 15.1618
R149 vdd_1v2.t362 vdd_1v2.n547 15.1618
R150 vdd_1v2.n554 vdd_1v2.t301 15.1618
R151 vdd_1v2.t301 vdd_1v2.n553 15.1618
R152 vdd_1v2.n549 vdd_1v2.t362 15.1618
R153 vdd_1v2.t379 vdd_1v2.n534 15.1618
R154 vdd_1v2.n541 vdd_1v2.t306 15.1618
R155 vdd_1v2.t306 vdd_1v2.n540 15.1618
R156 vdd_1v2.n536 vdd_1v2.t379 15.1618
R157 vdd_1v2.t383 vdd_1v2.n567 15.1618
R158 vdd_1v2.n574 vdd_1v2.t280 15.1618
R159 vdd_1v2.t280 vdd_1v2.n573 15.1618
R160 vdd_1v2.n569 vdd_1v2.t383 15.1618
R161 vdd_1v2.t0 vdd_1v2.t327 7.58168
R162 vdd_1v2.n528 vdd_1v2.t341 15.1618
R163 vdd_1v2.t341 vdd_1v2.n527 15.1618
R164 vdd_1v2.t360 vdd_1v2.n458 15.1618
R165 vdd_1v2.n461 vdd_1v2.t360 15.1618
R166 vdd_1v2.n561 vdd_1v2.t338 15.1618
R167 vdd_1v2.t338 vdd_1v2.n560 15.1618
R168 vdd_1v2.t381 vdd_1v2.n451 15.1618
R169 vdd_1v2.n454 vdd_1v2.t381 15.1618
R170 vdd_1v2.n581 vdd_1v2.t376 15.1618
R171 vdd_1v2.t376 vdd_1v2.n580 15.1618
R172 vdd_1v2.t0 vdd_1v2.t391 7.58243
R173 vdd_1v2.n441 vdd_1v2.t388 15.0005
R174 vdd_1v2.t388 vdd_1v2.n440 15.0005
R175 vdd_1v2.n524 vdd_1v2.t348 15.0005
R176 vdd_1v2.n517 vdd_1v2.t284 15.0005
R177 vdd_1v2.t284 vdd_1v2.n516 15.0005
R178 vdd_1v2.t161 vdd_1v2.n301 15.0005
R179 vdd_1v2.n302 vdd_1v2.t161 15.0005
R180 vdd_1v2.n163 vdd_1v2.t231 15.0005
R181 vdd_1v2.t231 vdd_1v2.n159 15.0005
R182 vdd_1v2.n281 vdd_1v2.t148 15.0005
R183 vdd_1v2.t219 vdd_1v2.n243 15.0005
R184 vdd_1v2.n246 vdd_1v2.t219 15.0005
R185 vdd_1v2.n277 vdd_1v2.t142 15.0005
R186 vdd_1v2.t142 vdd_1v2.n276 15.0005
R187 vdd_1v2.n180 vdd_1v2.t207 15.0005
R188 vdd_1v2.t207 vdd_1v2.n176 15.0005
R189 vdd_1v2.t135 vdd_1v2.n269 15.0005
R190 vdd_1v2.n270 vdd_1v2.t135 15.0005
R191 vdd_1v2.t196 vdd_1v2.n47 15.0005
R192 vdd_1v2.n287 vdd_1v2.t196 15.0005
R193 vdd_1v2.t148 vdd_1v2.n279 15.0005
R194 vdd_1v2.t113 vdd_1v2.t103 15.0005
R195 vdd_1v2.n143 vdd_1v2.t105 15.0005
R196 vdd_1v2.t115 vdd_1v2.n148 15.0005
R197 vdd_1v2.n139 vdd_1v2.t118 15.0005
R198 vdd_1v2.t121 vdd_1v2.n150 15.0005
R199 vdd_1v2.n0 vdd_1v2.t124 15.0005
R200 vdd_1v2.n144 vdd_1v2.t113 15.0005
R201 vdd_1v2.t105 vdd_1v2.n147 15.0005
R202 vdd_1v2.n140 vdd_1v2.t115 15.0005
R203 vdd_1v2.t118 vdd_1v2.n149 15.0005
R204 vdd_1v2.n136 vdd_1v2.t121 15.0005
R205 vdd_1v2.t124 vdd_1v2.n151 15.0005
R206 vdd_1v2.t68 vdd_1v2.t69 15.0005
R207 vdd_1v2.t72 vdd_1v2.n131 15.0005
R208 vdd_1v2.n125 vdd_1v2.t75 15.0005
R209 vdd_1v2.t78 vdd_1v2.n133 15.0005
R210 vdd_1v2.n121 vdd_1v2.t81 15.0005
R211 vdd_1v2.t84 vdd_1v2.n135 15.0005
R212 vdd_1v2.t0 vdd_1v2.n44 0.182487
R213 vdd_1v2.t69 vdd_1v2.n130 15.0005
R214 vdd_1v2.n126 vdd_1v2.t72 15.0005
R215 vdd_1v2.t75 vdd_1v2.n132 15.0005
R216 vdd_1v2.n122 vdd_1v2.t78 15.0005
R217 vdd_1v2.t81 vdd_1v2.n134 15.0005
R218 vdd_1v2.n118 vdd_1v2.t84 15.0005
R219 vdd_1v2.t87 vdd_1v2.n44 7.41026
R220 vdd_1v2.n42 vdd_1v2.t38 7.44903
R221 vdd_1v2.t40 vdd_1v2.n78 15.0005
R222 vdd_1v2.n64 vdd_1v2.t43 15.0005
R223 vdd_1v2.t46 vdd_1v2.n76 15.0005
R224 vdd_1v2.n68 vdd_1v2.t49 15.0005
R225 vdd_1v2.t52 vdd_1v2.n74 15.0005
R226 vdd_1v2.t57 vdd_1v2.t55 15.0005
R227 vdd_1v2.n62 vdd_1v2.t40 15.0005
R228 vdd_1v2.t43 vdd_1v2.n77 15.0005
R229 vdd_1v2.n65 vdd_1v2.t46 15.0005
R230 vdd_1v2.t49 vdd_1v2.n75 15.0005
R231 vdd_1v2.n69 vdd_1v2.t52 15.0005
R232 vdd_1v2.t55 vdd_1v2.n73 15.0005
R233 vdd_1v2.n115 vdd_1v2.t89 15.0005
R234 vdd_1v2.n113 vdd_1v2.t92 15.0005
R235 vdd_1v2.t94 vdd_1v2.n108 15.0005
R236 vdd_1v2.n106 vdd_1v2.t96 15.0005
R237 vdd_1v2.t98 vdd_1v2.n102 15.0005
R238 vdd_1v2.n100 vdd_1v2.t100 15.0005
R239 vdd_1v2.t61 vdd_1v2.n96 15.0005
R240 vdd_1v2.t89 vdd_1v2.n81 15.0005
R241 vdd_1v2.t92 vdd_1v2.n112 15.0005
R242 vdd_1v2.n109 vdd_1v2.t94 15.0005
R243 vdd_1v2.t96 vdd_1v2.n105 15.0005
R244 vdd_1v2.n103 vdd_1v2.t98 15.0005
R245 vdd_1v2.t100 vdd_1v2.n99 15.0005
R246 vdd_1v2.n97 vdd_1v2.t61 15.0005
R247 vdd_1v2.n307 vdd_1v2.t150 15.0005
R248 vdd_1v2.t150 vdd_1v2.n303 15.0005
R249 vdd_1v2.n295 vdd_1v2.t128 15.0005
R250 vdd_1v2.t128 vdd_1v2.n294 15.0005
R251 vdd_1v2.n254 vdd_1v2.t137 15.0005
R252 vdd_1v2.t137 vdd_1v2.n250 15.0005
R253 vdd_1v2.n261 vdd_1v2.t108 15.0005
R254 vdd_1v2.t108 vdd_1v2.n257 15.0005
R255 vdd_1v2.n7 vdd_1v2.t204 15.0005
R256 vdd_1v2.t204 vdd_1v2.t203 15.0005
R257 vdd_1v2.n175 vdd_1v2.t216 15.0005
R258 vdd_1v2.t216 vdd_1v2.n174 15.0005
R259 vdd_1v2.n41 vdd_1v2.t228 7.43463
R260 vdd_1v2.n158 vdd_1v2.t240 15.0005
R261 vdd_1v2.t240 vdd_1v2.n157 15.0005
R262 vdd_1v2.n449 vdd_1v2.t324 15.0005
R263 vdd_1v2.t324 vdd_1v2.n448 15.0005
R264 vdd_1v2.n379 vdd_1v2.t316 15.0005
R265 vdd_1v2.t316 vdd_1v2.n378 15.0005
R266 vdd_1v2.n370 vdd_1v2.t308 15.0005
R267 vdd_1v2.t308 vdd_1v2.n366 15.0005
R268 vdd_1v2.n363 vdd_1v2.t294 15.0005
R269 vdd_1v2.t294 vdd_1v2.n359 15.0005
R270 vdd_1v2.n349 vdd_1v2.t286 15.0005
R271 vdd_1v2.t286 vdd_1v2.n345 15.0005
R272 vdd_1v2.n358 vdd_1v2.t275 15.0005
R273 vdd_1v2.t275 vdd_1v2.n357 15.0005
R274 vdd_1v2.t348 vdd_1v2.n523 15.0005
R275 vdd_1v2.n510 vdd_1v2.t354 15.0005
R276 vdd_1v2.t291 vdd_1v2.n505 15.0005
R277 vdd_1v2.n506 vdd_1v2.t291 15.0005
R278 vdd_1v2.t354 vdd_1v2.n509 15.0005
R279 vdd_1v2.n551 vdd_1v2.t335 15.0005
R280 vdd_1v2.n555 vdd_1v2.t303 15.0005
R281 vdd_1v2.t303 vdd_1v2.n545 15.0005
R282 vdd_1v2.t335 vdd_1v2.n550 15.0005
R283 vdd_1v2.n538 vdd_1v2.t367 15.0005
R284 vdd_1v2.n542 vdd_1v2.t313 15.0005
R285 vdd_1v2.t313 vdd_1v2.n532 15.0005
R286 vdd_1v2.t367 vdd_1v2.n537 15.0005
R287 vdd_1v2.n571 vdd_1v2.t373 15.0005
R288 vdd_1v2.n575 vdd_1v2.t321 15.0005
R289 vdd_1v2.t321 vdd_1v2.n565 15.0005
R290 vdd_1v2.t373 vdd_1v2.n570 15.0005
R291 vdd_1v2.t0 vdd_1v2.t345 7.43049
R292 vdd_1v2.n529 vdd_1v2.t329 15.0005
R293 vdd_1v2.t329 vdd_1v2.n525 15.0005
R294 vdd_1v2.n463 vdd_1v2.t332 15.0005
R295 vdd_1v2.t332 vdd_1v2.n462 15.0005
R296 vdd_1v2.n562 vdd_1v2.t364 15.0005
R297 vdd_1v2.t364 vdd_1v2.n558 15.0005
R298 vdd_1v2.n456 vdd_1v2.t370 15.0005
R299 vdd_1v2.t370 vdd_1v2.n455 15.0005
R300 vdd_1v2.n582 vdd_1v2.t385 15.0005
R301 vdd_1v2.t385 vdd_1v2.n578 15.0005
R302 vdd_1v2.t0 vdd_1v2.t396 7.43049
R303 vdd_1v2.n401 vdd_1v2.t5 14.7941
R304 vdd_1v2.n403 vdd_1v2.t13 14.7941
R305 vdd_1v2.n402 vdd_1v2.t11 14.7941
R306 vdd_1v2.n604 vdd_1v2.t433 14.7941
R307 vdd_1v2.n606 vdd_1v2.t340 14.7941
R308 vdd_1v2.n605 vdd_1v2.t439 14.7941
R309 vdd_1v2.n426 vdd_1v2.n425 12.5504
R310 vdd_1v2.n400 vdd_1v2.n390 12.5504
R311 vdd_1v2.n629 vdd_1v2.n628 12.5504
R312 vdd_1v2.n603 vdd_1v2.n593 12.5504
R313 vdd_1v2.n408 vdd_1v2.n407 12.2609
R314 vdd_1v2.n611 vdd_1v2.n610 12.2609
R315 vdd_1v2.n434 vdd_1v2.n409 11.7601
R316 vdd_1v2.n637 vdd_1v2.n612 11.7601
R317 vdd_1v2.t0 vdd_1v2.t421 10.3283
R318 vdd_1v2.t0 vdd_1v2.t417 10.3283
R319 vdd_1v2.n428 vdd_1v2.n426 9.57599
R320 vdd_1v2.n400 vdd_1v2.n399 9.57599
R321 vdd_1v2.n631 vdd_1v2.n629 9.57599
R322 vdd_1v2.n603 vdd_1v2.n602 9.57599
R323 vdd_1v2.n415 vdd_1v2.n409 9.20939
R324 vdd_1v2.n618 vdd_1v2.n612 9.20939
R325 vdd_1v2.n405 vdd_1v2.n404 9.20898
R326 vdd_1v2.n608 vdd_1v2.n607 9.20898
R327 vdd_1v2.n222 vdd_1v2.n221 9.0408
R328 vdd_1v2.n227 vdd_1v2.n226 9.0408
R329 vdd_1v2.n228 vdd_1v2.n218 9.0408
R330 vdd_1v2.n233 vdd_1v2.n232 9.0408
R331 vdd_1v2.n235 vdd_1v2.n215 9.0408
R332 vdd_1v2.n240 vdd_1v2.n239 9.0408
R333 vdd_1v2.n193 vdd_1v2.n191 9.0408
R334 vdd_1v2.n198 vdd_1v2.n197 9.0408
R335 vdd_1v2.n200 vdd_1v2.n188 9.0408
R336 vdd_1v2.n205 vdd_1v2.n204 9.0408
R337 vdd_1v2.n207 vdd_1v2.n185 9.0408
R338 vdd_1v2.n212 vdd_1v2.n211 9.0408
R339 vdd_1v2.n425 vdd_1v2.n424 9.0408
R340 vdd_1v2.n423 vdd_1v2.n422 9.0408
R341 vdd_1v2.n431 vdd_1v2.n430 9.0408
R342 vdd_1v2.n429 vdd_1v2.n428 9.0408
R343 vdd_1v2.n399 vdd_1v2.n398 9.0408
R344 vdd_1v2.n397 vdd_1v2.n396 9.0408
R345 vdd_1v2.n385 vdd_1v2.n384 9.0408
R346 vdd_1v2.n390 vdd_1v2.n389 9.0408
R347 vdd_1v2.n628 vdd_1v2.n627 9.0408
R348 vdd_1v2.n626 vdd_1v2.n625 9.0408
R349 vdd_1v2.n634 vdd_1v2.n633 9.0408
R350 vdd_1v2.n632 vdd_1v2.n631 9.0408
R351 vdd_1v2.n602 vdd_1v2.n601 9.0408
R352 vdd_1v2.n600 vdd_1v2.n599 9.0408
R353 vdd_1v2.n588 vdd_1v2.n587 9.0408
R354 vdd_1v2.n593 vdd_1v2.n592 9.0408
R355 vdd_1v2.n209 vdd_1v2.n208 9.0005
R356 vdd_1v2.n184 vdd_1v2.n183 9.0005
R357 vdd_1v2.n202 vdd_1v2.n201 9.0005
R358 vdd_1v2.n187 vdd_1v2.n186 9.0005
R359 vdd_1v2.n195 vdd_1v2.n194 9.0005
R360 vdd_1v2.n190 vdd_1v2.n189 9.0005
R361 vdd_1v2.n230 vdd_1v2.n229 9.0005
R362 vdd_1v2.n217 vdd_1v2.n216 9.0005
R363 vdd_1v2.n224 vdd_1v2.n223 9.0005
R364 vdd_1v2.n220 vdd_1v2.n219 9.0005
R365 vdd_1v2.n237 vdd_1v2.n236 9.0005
R366 vdd_1v2.n214 vdd_1v2.n213 9.0005
R367 vdd_1v2.n421 vdd_1v2.n410 9.0005
R368 vdd_1v2.n433 vdd_1v2.n432 9.0005
R369 vdd_1v2.n412 vdd_1v2.n411 9.0005
R370 vdd_1v2.n427 vdd_1v2.n414 9.0005
R371 vdd_1v2.n420 vdd_1v2.n419 9.0005
R372 vdd_1v2.n417 vdd_1v2.n416 9.0005
R373 vdd_1v2.n395 vdd_1v2.n394 9.0005
R374 vdd_1v2.n392 vdd_1v2.n391 9.0005
R375 vdd_1v2.n387 vdd_1v2.n386 9.0005
R376 vdd_1v2.n383 vdd_1v2.n382 9.0005
R377 vdd_1v2.n624 vdd_1v2.n613 9.0005
R378 vdd_1v2.n636 vdd_1v2.n635 9.0005
R379 vdd_1v2.n615 vdd_1v2.n614 9.0005
R380 vdd_1v2.n630 vdd_1v2.n617 9.0005
R381 vdd_1v2.n623 vdd_1v2.n622 9.0005
R382 vdd_1v2.n620 vdd_1v2.n619 9.0005
R383 vdd_1v2.n598 vdd_1v2.n597 9.0005
R384 vdd_1v2.n595 vdd_1v2.n594 9.0005
R385 vdd_1v2.n590 vdd_1v2.n589 9.0005
R386 vdd_1v2.n586 vdd_1v2.n585 9.0005
R387 vdd_1v2.t0 vdd_1v2.t419 8.7647
R388 vdd_1v2.t0 vdd_1v2.t415 8.7647
R389 vdd_1v2.n55 vdd_1v2.t414 8.7647
R390 vdd_1v2.n55 vdd_1v2.t401 8.7647
R391 vdd_1v2.n58 vdd_1v2.t409 8.7647
R392 vdd_1v2.n58 vdd_1v2.t411 8.7647
R393 vdd_1v2.t0 vdd_1v2.n58 0.392142
R394 vdd_1v2.t0 vdd_1v2.n54 0.803578
R395 vdd_1v2.t224 vdd_1v2.n221 8.49536
R396 vdd_1v2.n226 vdd_1v2.t224 8.49536
R397 vdd_1v2.t212 vdd_1v2.n218 8.49536
R398 vdd_1v2.n232 vdd_1v2.t212 8.49536
R399 vdd_1v2.t200 vdd_1v2.n215 8.49536
R400 vdd_1v2.n239 vdd_1v2.t200 8.49536
R401 vdd_1v2.t226 vdd_1v2.n191 8.49536
R402 vdd_1v2.n197 vdd_1v2.t226 8.49536
R403 vdd_1v2.t214 vdd_1v2.n188 8.49536
R404 vdd_1v2.n204 vdd_1v2.t214 8.49536
R405 vdd_1v2.t202 vdd_1v2.n185 8.49536
R406 vdd_1v2.n211 vdd_1v2.t202 8.49536
R407 vdd_1v2.t4 vdd_1v2.n423 8.49536
R408 vdd_1v2.n424 vdd_1v2.t4 8.49536
R409 vdd_1v2.n430 vdd_1v2.t18 8.49536
R410 vdd_1v2.t18 vdd_1v2.n429 8.49536
R411 vdd_1v2.t2 vdd_1v2.n397 8.49536
R412 vdd_1v2.n398 vdd_1v2.t2 8.49536
R413 vdd_1v2.t1 vdd_1v2.n384 8.49536
R414 vdd_1v2.n389 vdd_1v2.t1 8.49536
R415 vdd_1v2.t450 vdd_1v2.n626 8.49536
R416 vdd_1v2.n627 vdd_1v2.t450 8.49536
R417 vdd_1v2.n633 vdd_1v2.t378 8.49536
R418 vdd_1v2.t378 vdd_1v2.n632 8.49536
R419 vdd_1v2.t432 vdd_1v2.n600 8.49536
R420 vdd_1v2.n601 vdd_1v2.t432 8.49536
R421 vdd_1v2.t353 vdd_1v2.n587 8.49536
R422 vdd_1v2.n592 vdd_1v2.t353 8.49536
R423 vdd_1v2.t0 vdd_1v2.n166 0.576931
R424 vdd_1v2.t224 vdd_1v2.n225 8.46888
R425 vdd_1v2.t212 vdd_1v2.n231 8.46888
R426 vdd_1v2.t200 vdd_1v2.n238 8.46888
R427 vdd_1v2.t226 vdd_1v2.n196 8.46888
R428 vdd_1v2.t214 vdd_1v2.n203 8.46888
R429 vdd_1v2.t202 vdd_1v2.n210 8.46888
R430 vdd_1v2.t4 vdd_1v2.n418 8.46888
R431 vdd_1v2.t18 vdd_1v2.n413 8.46888
R432 vdd_1v2.t2 vdd_1v2.n393 8.46888
R433 vdd_1v2.t1 vdd_1v2.n388 8.46888
R434 vdd_1v2.t450 vdd_1v2.n621 8.46888
R435 vdd_1v2.t378 vdd_1v2.n616 8.46888
R436 vdd_1v2.t432 vdd_1v2.n596 8.46888
R437 vdd_1v2.t353 vdd_1v2.n591 8.46888
R438 vdd_1v2.t0 vdd_1v2.n52 0.384979
R439 vdd_1v2.t0 vdd_1v2.t418 7.57756
R440 vdd_1v2.t0 vdd_1v2.t406 7.57756
R441 vdd_1v2.n343 vdd_1v2.t177 7.49014
R442 vdd_1v2.t177 vdd_1v2.n312 7.49014
R443 vdd_1v2.t177 vdd_1v2.n314 7.49014
R444 vdd_1v2.t177 vdd_1v2.n340 7.49014
R445 vdd_1v2.n328 vdd_1v2.t153 7.49014
R446 vdd_1v2.t153 vdd_1v2.n318 7.49014
R447 vdd_1v2.t153 vdd_1v2.n320 7.49014
R448 vdd_1v2.t153 vdd_1v2.n325 7.49014
R449 vdd_1v2.n482 vdd_1v2.t64 7.49014
R450 vdd_1v2.t64 vdd_1v2.n471 7.49014
R451 vdd_1v2.t64 vdd_1v2.n473 7.49014
R452 vdd_1v2.t64 vdd_1v2.n479 7.49014
R453 vdd_1v2.n497 vdd_1v2.t258 7.49014
R454 vdd_1v2.t258 vdd_1v2.n465 7.49014
R455 vdd_1v2.t258 vdd_1v2.n467 7.49014
R456 vdd_1v2.t258 vdd_1v2.n494 7.49014
R457 vdd_1v2.t102 vdd_1v2.n146 7.31579
R458 vdd_1v2.n129 vdd_1v2.t67 7.31579
R459 vdd_1v2.t58 vdd_1v2.n72 7.31579
R460 vdd_1v2.n396 vdd_1v2.t7 7.13608
R461 vdd_1v2.n599 vdd_1v2.t437 7.13608
R462 vdd_1v2.n385 vdd_1v2.t3 7.13608
R463 vdd_1v2.n588 vdd_1v2.t359 7.13608
R464 vdd_1v2.t201 vdd_1v2.n242 7.13081
R465 vdd_1v2.n192 vdd_1v2.t238 6.01108
R466 vdd_1v2.n51 vdd_1v2.t236 6.01108
R467 vdd_1v2.n55 vdd_1v2.t412 5.9747
R468 vdd_1v2.n53 vdd_1v2.t402 5.9747
R469 vdd_1v2.n46 vdd_1v2.n80 8.93097
R470 vdd_1v2.n421 vdd_1v2.t21 5.79408
R471 vdd_1v2.n624 vdd_1v2.t451 5.79408
R472 vdd_1v2.n432 vdd_1v2.t22 5.79408
R473 vdd_1v2.n635 vdd_1v2.t393 5.79408
R474 vdd_1v2.n117 vdd_1v2.t91 5.56245
R475 vdd_1v2.n94 vdd_1v2.t62 5.56245
R476 vdd_1v2.n92 vdd_1v2.t63 5.56245
R477 vdd_1v2.n90 vdd_1v2.t99 5.56245
R478 vdd_1v2.n88 vdd_1v2.t97 5.56245
R479 vdd_1v2.n86 vdd_1v2.t95 5.56245
R480 vdd_1v2.n84 vdd_1v2.t93 5.56245
R481 vdd_1v2.n82 vdd_1v2.t90 5.56245
R482 vdd_1v2.t177 vdd_1v2.n342 4.98183
R483 vdd_1v2.t177 vdd_1v2.n316 4.98183
R484 vdd_1v2.t153 vdd_1v2.n327 4.98183
R485 vdd_1v2.t153 vdd_1v2.n322 4.98183
R486 vdd_1v2.t64 vdd_1v2.n481 4.98183
R487 vdd_1v2.t64 vdd_1v2.n475 4.98183
R488 vdd_1v2.t258 vdd_1v2.n496 4.98183
R489 vdd_1v2.t258 vdd_1v2.n469 4.98183
R490 vdd_1v2.n80 vdd_1v2.n79 4.7349
R491 vdd_1v2.n401 vdd_1v2.n400 4.7085
R492 vdd_1v2.n604 vdd_1v2.n603 4.7085
R493 vdd_1v2.t0 vdd_1v2.n637 4.5005
R494 vdd_1v2.n618 vdd_1v2.t0 4.5005
R495 vdd_1v2.t0 vdd_1v2.n434 4.5005
R496 vdd_1v2.n415 vdd_1v2.t0 4.5005
R497 vdd_1v2.n46 vdd_1v2.t60 3.11596
R498 vdd_1v2.n404 vdd_1v2.t0 4.5005
R499 vdd_1v2.n607 vdd_1v2.t0 4.5005
R500 vdd_1v2.n54 vdd_1v2.n53 0.0599303
R501 vdd_1v2.n54 vdd_1v2.n310 0.175711
R502 vdd_1v2.t0 vdd_1v2.n56 2.96401
R503 vdd_1v2.n409 vdd_1v2.n408 3.15879
R504 vdd_1v2.n612 vdd_1v2.n611 3.15879
R505 vdd_1v2.n433 vdd_1v2.n410 2.9749
R506 vdd_1v2.n407 vdd_1v2.n406 2.9749
R507 vdd_1v2.n403 vdd_1v2.n402 2.9749
R508 vdd_1v2.n636 vdd_1v2.n613 2.9749
R509 vdd_1v2.n610 vdd_1v2.n609 2.9749
R510 vdd_1v2.n606 vdd_1v2.n605 2.9749
R511 vdd_1v2.t0 vdd_1v2.n46 0.694976
R512 vdd_1v2.n435 vdd_1v2.t390 2.61969
R513 vdd_1v2.n511 vdd_1v2.t285 2.61969
R514 vdd_1v2.n296 vdd_1v2.t163 2.61969
R515 vdd_1v2.n165 vdd_1v2.t233 2.61969
R516 vdd_1v2.n244 vdd_1v2.t221 2.61969
R517 vdd_1v2.n271 vdd_1v2.t143 2.61969
R518 vdd_1v2.n182 vdd_1v2.t209 2.61969
R519 vdd_1v2.n264 vdd_1v2.t136 2.61969
R520 vdd_1v2.n49 vdd_1v2.t198 2.61969
R521 vdd_1v2.n280 vdd_1v2.t149 2.61969
R522 vdd_1v2.n309 vdd_1v2.t152 2.61969
R523 vdd_1v2.n289 vdd_1v2.t130 2.61969
R524 vdd_1v2.n256 vdd_1v2.t139 2.61969
R525 vdd_1v2.n263 vdd_1v2.t110 2.61969
R526 vdd_1v2.n169 vdd_1v2.t218 2.61969
R527 vdd_1v2.n152 vdd_1v2.t242 2.61969
R528 vdd_1v2.n442 vdd_1v2.t326 2.61969
R529 vdd_1v2.n373 vdd_1v2.t318 2.61969
R530 vdd_1v2.n372 vdd_1v2.t310 2.61969
R531 vdd_1v2.n365 vdd_1v2.t296 2.61969
R532 vdd_1v2.n351 vdd_1v2.t288 2.61969
R533 vdd_1v2.n352 vdd_1v2.t277 2.61969
R534 vdd_1v2.n518 vdd_1v2.t350 2.61969
R535 vdd_1v2.n507 vdd_1v2.t293 2.61969
R536 vdd_1v2.n498 vdd_1v2.t355 2.61969
R537 vdd_1v2.n557 vdd_1v2.t305 2.61969
R538 vdd_1v2.n546 vdd_1v2.t336 2.61969
R539 vdd_1v2.n544 vdd_1v2.t315 2.61969
R540 vdd_1v2.n533 vdd_1v2.t368 2.61969
R541 vdd_1v2.n577 vdd_1v2.t323 2.61969
R542 vdd_1v2.n566 vdd_1v2.t374 2.61969
R543 vdd_1v2.n531 vdd_1v2.t331 2.61969
R544 vdd_1v2.n457 vdd_1v2.t334 2.61969
R545 vdd_1v2.n564 vdd_1v2.t366 2.61969
R546 vdd_1v2.n450 vdd_1v2.t372 2.61969
R547 vdd_1v2.n584 vdd_1v2.t387 2.61969
R548 vdd_1v2.n437 vdd_1v2.t389 2.61953
R549 vdd_1v2.n514 vdd_1v2.t283 2.61953
R550 vdd_1v2.n299 vdd_1v2.t147 2.61953
R551 vdd_1v2.n160 vdd_1v2.t232 2.61953
R552 vdd_1v2.n283 vdd_1v2.t37 2.61953
R553 vdd_1v2.n248 vdd_1v2.t220 2.61953
R554 vdd_1v2.n274 vdd_1v2.t132 2.61953
R555 vdd_1v2.n177 vdd_1v2.t208 2.61953
R556 vdd_1v2.n267 vdd_1v2.t134 2.61953
R557 vdd_1v2.n48 vdd_1v2.t197 2.61953
R558 vdd_1v2.n304 vdd_1v2.t151 2.61953
R559 vdd_1v2.n291 vdd_1v2.t129 2.61953
R560 vdd_1v2.n251 vdd_1v2.t138 2.61953
R561 vdd_1v2.n258 vdd_1v2.t35 2.61953
R562 vdd_1v2.n172 vdd_1v2.t215 2.61953
R563 vdd_1v2.n168 vdd_1v2.t227 2.61953
R564 vdd_1v2.n155 vdd_1v2.t239 2.61953
R565 vdd_1v2.n444 vdd_1v2.t325 2.61953
R566 vdd_1v2.n375 vdd_1v2.t317 2.61953
R567 vdd_1v2.n367 vdd_1v2.t309 2.61953
R568 vdd_1v2.n360 vdd_1v2.t295 2.61953
R569 vdd_1v2.n346 vdd_1v2.t287 2.61953
R570 vdd_1v2.n354 vdd_1v2.t276 2.61953
R571 vdd_1v2.n520 vdd_1v2.t349 2.61953
R572 vdd_1v2.n503 vdd_1v2.t292 2.61953
R573 vdd_1v2.n500 vdd_1v2.t356 2.61953
R574 vdd_1v2.n552 vdd_1v2.t302 2.61953
R575 vdd_1v2.n548 vdd_1v2.t337 2.61953
R576 vdd_1v2.n539 vdd_1v2.t307 2.61953
R577 vdd_1v2.n535 vdd_1v2.t369 2.61953
R578 vdd_1v2.n572 vdd_1v2.t281 2.61953
R579 vdd_1v2.n568 vdd_1v2.t375 2.61953
R580 vdd_1v2.t0 vdd_1v2.t328 3.10013
R581 vdd_1v2.n526 vdd_1v2.t330 2.61953
R582 vdd_1v2.n460 vdd_1v2.t333 2.61953
R583 vdd_1v2.n559 vdd_1v2.t339 2.61953
R584 vdd_1v2.n453 vdd_1v2.t371 2.61953
R585 vdd_1v2.n579 vdd_1v2.t377 2.61953
R586 vdd_1v2.t0 vdd_1v2.n241 2.29859
R587 vdd_1v2.t0 vdd_1v2.n60 0.386379
R588 vdd_1v2.n60 vdd_1v2.n446 0.210634
R589 vdd_1v2.n408 vdd_1v2.n405 1.94439
R590 vdd_1v2.n611 vdd_1v2.n608 1.94439
R591 vdd_1v2.t206 vdd_1v2.t0 0.500681
R592 vdd_1v2.t0 vdd_1v2.n278 0.57214
R593 vdd_1v2.t0 vdd_1v2.n273 0.563189
R594 vdd_1v2.n284 vdd_1v2.n283 1.62701
R595 vdd_1v2.n249 vdd_1v2.n248 1.62663
R596 vdd_1v2.n310 vdd_1v2.n50 0.0553937
R597 vdd_1v2.n432 vdd_1v2.n431 1.31519
R598 vdd_1v2.n422 vdd_1v2.n421 1.31519
R599 vdd_1v2.n635 vdd_1v2.n634 1.31519
R600 vdd_1v2.n625 vdd_1v2.n624 1.31519
R601 vdd_1v2.n426 vdd_1v2.n415 1.11139
R602 vdd_1v2.n629 vdd_1v2.n618 1.11139
R603 vdd_1v2.n434 vdd_1v2.n433 1.11098
R604 vdd_1v2.n404 vdd_1v2.n403 1.11098
R605 vdd_1v2.n637 vdd_1v2.n636 1.11098
R606 vdd_1v2.n607 vdd_1v2.n606 1.11098
R607 vdd_1v2.n145 vdd_1v2.t106 1.10264
R608 vdd_1v2.t107 vdd_1v2.n142 1.10264
R609 vdd_1v2.n141 vdd_1v2.t117 1.10264
R610 vdd_1v2.t120 vdd_1v2.n138 1.10264
R611 vdd_1v2.n137 vdd_1v2.t123 1.10264
R612 vdd_1v2.n151 vdd_1v2.n40 0.307269
R613 vdd_1v2.t71 vdd_1v2.n128 1.10264
R614 vdd_1v2.n127 vdd_1v2.t74 1.10264
R615 vdd_1v2.t77 vdd_1v2.n124 1.10264
R616 vdd_1v2.n123 vdd_1v2.t80 1.10264
R617 vdd_1v2.t83 vdd_1v2.n120 1.10264
R618 vdd_1v2.n119 vdd_1v2.t86 1.10264
R619 vdd_1v2.t54 vdd_1v2.n71 1.10264
R620 vdd_1v2.n70 vdd_1v2.t51 1.10264
R621 vdd_1v2.t48 vdd_1v2.n67 1.10264
R622 vdd_1v2.n66 vdd_1v2.t45 1.10264
R623 vdd_1v2.t42 vdd_1v2.n63 1.10264
R624 vdd_1v2.n7 vdd_1v2.n242 1.06405
R625 vdd_1v2.t203 vdd_1v2.n242 1.06405
R626 vdd_1v2.n335 vdd_1v2.n334 0.960905
R627 vdd_1v2.n334 vdd_1v2.n333 0.960905
R628 vdd_1v2.n333 vdd_1v2.n332 0.960905
R629 vdd_1v2.n487 vdd_1v2.n486 0.960905
R630 vdd_1v2.n488 vdd_1v2.n487 0.960905
R631 vdd_1v2.n489 vdd_1v2.n488 0.960905
R632 vdd_1v2.n439 vdd_1v2.n435 0.959599
R633 vdd_1v2.n513 vdd_1v2.n511 0.959599
R634 vdd_1v2.n298 vdd_1v2.n296 0.959599
R635 vdd_1v2.n166 vdd_1v2.n165 0.959599
R636 vdd_1v2.n245 vdd_1v2.n244 0.959599
R637 vdd_1v2.n273 vdd_1v2.n271 0.959599
R638 vdd_1v2.n56 vdd_1v2.n182 0.959599
R639 vdd_1v2.n37 vdd_1v2.n264 0.959599
R640 vdd_1v2.n49 vdd_1v2.n288 0.959599
R641 vdd_1v2.n284 vdd_1v2.n280 0.959599
R642 vdd_1v2.n34 vdd_1v2.n309 0.959599
R643 vdd_1v2.n293 vdd_1v2.n289 0.959599
R644 vdd_1v2.n31 vdd_1v2.n256 0.959599
R645 vdd_1v2.n32 vdd_1v2.n263 0.959599
R646 vdd_1v2.n39 vdd_1v2.n169 0.959599
R647 vdd_1v2.t0 vdd_1v2.t230 3.04656
R648 vdd_1v2.n10 vdd_1v2.n152 0.959599
R649 vdd_1v2.n447 vdd_1v2.n442 0.959599
R650 vdd_1v2.n377 vdd_1v2.n373 0.959599
R651 vdd_1v2.n3 vdd_1v2.n372 0.959599
R652 vdd_1v2.n4 vdd_1v2.n365 0.959599
R653 vdd_1v2.n6 vdd_1v2.n351 0.959599
R654 vdd_1v2.n356 vdd_1v2.n352 0.959599
R655 vdd_1v2.n522 vdd_1v2.n518 0.959599
R656 vdd_1v2.n507 vdd_1v2.n18 0.959599
R657 vdd_1v2.n19 vdd_1v2.n498 0.959599
R658 vdd_1v2.n557 vdd_1v2.n556 0.959599
R659 vdd_1v2.n16 vdd_1v2.n546 0.959599
R660 vdd_1v2.n544 vdd_1v2.n543 0.959599
R661 vdd_1v2.n11 vdd_1v2.n533 0.959599
R662 vdd_1v2.n577 vdd_1v2.n576 0.959599
R663 vdd_1v2.n20 vdd_1v2.n566 0.959599
R664 vdd_1v2.t0 vdd_1v2.t347 2.9619
R665 vdd_1v2.n531 vdd_1v2.n530 0.959599
R666 vdd_1v2.n27 vdd_1v2.n457 0.959599
R667 vdd_1v2.n564 vdd_1v2.n563 0.959599
R668 vdd_1v2.n25 vdd_1v2.n450 0.959599
R669 vdd_1v2.n584 vdd_1v2.n583 0.959599
R670 vdd_1v2.t398 vdd_1v2.t0 2.9619
R671 vdd_1v2.n438 vdd_1v2.n437 0.959427
R672 vdd_1v2.n515 vdd_1v2.n514 0.959427
R673 vdd_1v2.n300 vdd_1v2.n299 0.959427
R674 vdd_1v2.n161 vdd_1v2.n160 0.959427
R675 vdd_1v2.n248 vdd_1v2.n247 0.959427
R676 vdd_1v2.n275 vdd_1v2.n274 0.959427
R677 vdd_1v2.n178 vdd_1v2.n177 0.959427
R678 vdd_1v2.n267 vdd_1v2.n265 0.959427
R679 vdd_1v2.n286 vdd_1v2.n48 0.959427
R680 vdd_1v2.n305 vdd_1v2.n304 0.959427
R681 vdd_1v2.n292 vdd_1v2.n291 0.959427
R682 vdd_1v2.n252 vdd_1v2.n251 0.959427
R683 vdd_1v2.n259 vdd_1v2.n258 0.959427
R684 vdd_1v2.n172 vdd_1v2.n170 0.959427
R685 vdd_1v2.n168 vdd_1v2.n167 0.959427
R686 vdd_1v2.n155 vdd_1v2.n153 0.959427
R687 vdd_1v2.n445 vdd_1v2.n444 0.959427
R688 vdd_1v2.n376 vdd_1v2.n375 0.959427
R689 vdd_1v2.n368 vdd_1v2.n367 0.959427
R690 vdd_1v2.n361 vdd_1v2.n360 0.959427
R691 vdd_1v2.n347 vdd_1v2.n346 0.959427
R692 vdd_1v2.n355 vdd_1v2.n354 0.959427
R693 vdd_1v2.n521 vdd_1v2.n520 0.959427
R694 vdd_1v2.n504 vdd_1v2.n503 0.959427
R695 vdd_1v2.n500 vdd_1v2.n499 0.959427
R696 vdd_1v2.n554 vdd_1v2.n552 0.959427
R697 vdd_1v2.n548 vdd_1v2.n547 0.959427
R698 vdd_1v2.n541 vdd_1v2.n539 0.959427
R699 vdd_1v2.n535 vdd_1v2.n534 0.959427
R700 vdd_1v2.n574 vdd_1v2.n572 0.959427
R701 vdd_1v2.n568 vdd_1v2.n567 0.959427
R702 vdd_1v2.n528 vdd_1v2.n526 0.959427
R703 vdd_1v2.n460 vdd_1v2.n458 0.959427
R704 vdd_1v2.n561 vdd_1v2.n559 0.959427
R705 vdd_1v2.n453 vdd_1v2.n451 0.959427
R706 vdd_1v2.n581 vdd_1v2.n579 0.959427
R707 vdd_1v2.n437 vdd_1v2.n436 0.959048
R708 vdd_1v2.n514 vdd_1v2.n512 0.959048
R709 vdd_1v2.n299 vdd_1v2.n297 0.959048
R710 vdd_1v2.n162 vdd_1v2.n160 0.959048
R711 vdd_1v2.n283 vdd_1v2.n282 0.959048
R712 vdd_1v2.n274 vdd_1v2.n272 0.959048
R713 vdd_1v2.n179 vdd_1v2.n177 0.959048
R714 vdd_1v2.n268 vdd_1v2.n267 0.959048
R715 vdd_1v2.n47 vdd_1v2.n48 0.959048
R716 vdd_1v2.n306 vdd_1v2.n304 0.959048
R717 vdd_1v2.n291 vdd_1v2.n290 0.959048
R718 vdd_1v2.n253 vdd_1v2.n251 0.959048
R719 vdd_1v2.n260 vdd_1v2.n258 0.959048
R720 vdd_1v2.n173 vdd_1v2.n172 0.959048
R721 vdd_1v2.n1 vdd_1v2.n168 0.959048
R722 vdd_1v2.n156 vdd_1v2.n155 0.959048
R723 vdd_1v2.n444 vdd_1v2.n443 0.959048
R724 vdd_1v2.n375 vdd_1v2.n374 0.959048
R725 vdd_1v2.n369 vdd_1v2.n367 0.959048
R726 vdd_1v2.n362 vdd_1v2.n360 0.959048
R727 vdd_1v2.n348 vdd_1v2.n346 0.959048
R728 vdd_1v2.n354 vdd_1v2.n353 0.959048
R729 vdd_1v2.n520 vdd_1v2.n519 0.959048
R730 vdd_1v2.n503 vdd_1v2.n502 0.959048
R731 vdd_1v2.n501 vdd_1v2.n500 0.959048
R732 vdd_1v2.n553 vdd_1v2.n552 0.959048
R733 vdd_1v2.n549 vdd_1v2.n548 0.959048
R734 vdd_1v2.n540 vdd_1v2.n539 0.959048
R735 vdd_1v2.n536 vdd_1v2.n535 0.959048
R736 vdd_1v2.n573 vdd_1v2.n572 0.959048
R737 vdd_1v2.n569 vdd_1v2.n568 0.959048
R738 vdd_1v2.n527 vdd_1v2.n526 0.959048
R739 vdd_1v2.n461 vdd_1v2.n460 0.959048
R740 vdd_1v2.n560 vdd_1v2.n559 0.959048
R741 vdd_1v2.n454 vdd_1v2.n453 0.959048
R742 vdd_1v2.n580 vdd_1v2.n579 0.959048
R743 vdd_1v2.t0 vdd_1v2.t392 3.09938
R744 vdd_1v2.n23 vdd_1v2.n435 0.958861
R745 vdd_1v2.n8 vdd_1v2.n511 0.958861
R746 vdd_1v2.n59 vdd_1v2.n296 0.958861
R747 vdd_1v2.n165 vdd_1v2.n164 0.958861
R748 vdd_1v2.n249 vdd_1v2.n244 0.958861
R749 vdd_1v2.n278 vdd_1v2.n271 0.958861
R750 vdd_1v2.n182 vdd_1v2.n181 0.958861
R751 vdd_1v2.n266 vdd_1v2.n264 0.958861
R752 vdd_1v2.n47 vdd_1v2.n49 0.958861
R753 vdd_1v2.n35 vdd_1v2.n280 0.958861
R754 vdd_1v2.n309 vdd_1v2.n308 0.958861
R755 vdd_1v2.n33 vdd_1v2.n289 0.958861
R756 vdd_1v2.n256 vdd_1v2.n255 0.958861
R757 vdd_1v2.n263 vdd_1v2.n262 0.958861
R758 vdd_1v2.n171 vdd_1v2.n169 0.958861
R759 vdd_1v2.n154 vdd_1v2.n152 0.958861
R760 vdd_1v2.n61 vdd_1v2.n442 0.958861
R761 vdd_1v2.n380 vdd_1v2.n373 0.958861
R762 vdd_1v2.n372 vdd_1v2.n371 0.958861
R763 vdd_1v2.n365 vdd_1v2.n364 0.958861
R764 vdd_1v2.n351 vdd_1v2.n350 0.958861
R765 vdd_1v2.n5 vdd_1v2.n352 0.958861
R766 vdd_1v2.n9 vdd_1v2.n518 0.958861
R767 vdd_1v2.n17 vdd_1v2.n507 0.958861
R768 vdd_1v2.n508 vdd_1v2.n498 0.958861
R769 vdd_1v2.n13 vdd_1v2.n557 0.958861
R770 vdd_1v2.n546 vdd_1v2.n12 0.958861
R771 vdd_1v2.n21 vdd_1v2.n544 0.958861
R772 vdd_1v2.n533 vdd_1v2.n22 0.958861
R773 vdd_1v2.n29 vdd_1v2.n577 0.958861
R774 vdd_1v2.n566 vdd_1v2.n28 0.958861
R775 vdd_1v2.n26 vdd_1v2.n531 0.958861
R776 vdd_1v2.n459 vdd_1v2.n457 0.958861
R777 vdd_1v2.n24 vdd_1v2.n564 0.958861
R778 vdd_1v2.n452 vdd_1v2.n450 0.958861
R779 vdd_1v2.n30 vdd_1v2.n584 0.958861
R780 vdd_1v2.n285 vdd_1v2.t0 0.384223
R781 vdd_1v2.n45 vdd_1v2.n381 0.39397
R782 vdd_1v2.n206 vdd_1v2.n205 0.810588
R783 vdd_1v2.n199 vdd_1v2.n198 0.801788
R784 vdd_1v2.n193 vdd_1v2.n192 0.801788
R785 vdd_1v2.n57 vdd_1v2.n227 0.801788
R786 vdd_1v2.n222 vdd_1v2.n51 0.801788
R787 vdd_1v2.n234 vdd_1v2.n233 0.799588
R788 vdd_1v2.n235 vdd_1v2.n234 0.795188
R789 vdd_1v2.n200 vdd_1v2.n199 0.792988
R790 vdd_1v2.n228 vdd_1v2.n57 0.792988
R791 vdd_1v2.n207 vdd_1v2.n206 0.784188
R792 vdd_1v2.n73 vdd_1v2.n72 0.694078
R793 vdd_1v2.n130 vdd_1v2.n129 0.694078
R794 vdd_1v2.n146 vdd_1v2.n144 0.694078
R795 vdd_1v2.t103 vdd_1v2.n146 0.694078
R796 vdd_1v2.t68 vdd_1v2.n129 0.694078
R797 vdd_1v2.n72 vdd_1v2.t57 0.694078
R798 vdd_1v2.n52 vdd_1v2.n243 0.688887
R799 vdd_1v2.n285 vdd_1v2.n279 0.688887
R800 vdd_1v2.n234 vdd_1v2.t0 2.45781
R801 vdd_1v2 vdd_1v2.t0 0.673714
R802 vdd_1v2.t0 vdd_1v2.n14 0.324207
R803 vdd_1v2.n164 vdd_1v2.t0 0.566748
R804 vdd_1v2.n181 vdd_1v2.t0 0.56078
R805 vdd_1v2.n245 vdd_1v2.t0 0.559924
R806 vdd_1v2.n241 vdd_1v2.n212 0.559105
R807 vdd_1v2.n117 vdd_1v2.n116 0.551745
R808 vdd_1v2.n95 vdd_1v2.n94 0.551745
R809 vdd_1v2.n92 vdd_1v2.n91 0.551745
R810 vdd_1v2.n101 vdd_1v2.n90 0.551745
R811 vdd_1v2.n88 vdd_1v2.n87 0.551745
R812 vdd_1v2.n107 vdd_1v2.n86 0.551745
R813 vdd_1v2.n84 vdd_1v2.n83 0.551745
R814 vdd_1v2.n114 vdd_1v2.n82 0.551745
R815 vdd_1v2.n36 vdd_1v2.n117 0.551399
R816 vdd_1v2.n94 vdd_1v2.n93 0.551399
R817 vdd_1v2.n98 vdd_1v2.n92 0.551399
R818 vdd_1v2.n90 vdd_1v2.n89 0.551399
R819 vdd_1v2.n104 vdd_1v2.n88 0.551399
R820 vdd_1v2.n86 vdd_1v2.n85 0.551399
R821 vdd_1v2.n110 vdd_1v2.n84 0.551399
R822 vdd_1v2.n111 vdd_1v2.n82 0.551399
R823 vdd_1v2.t0 vdd_1v2.n37 0.323587
R824 vdd_1v2.n285 vdd_1v2.n284 0.402569
R825 vdd_1v2.n52 vdd_1v2.n249 0.402569
R826 vdd_1v2.n288 vdd_1v2.t0 0.392918
R827 vdd_1v2.t0 vdd_1v2.n51 2.49346
R828 vdd_1v2.t0 vdd_1v2.n57 2.49871
R829 vdd_1v2.n446 vdd_1v2.n14 0.361769
R830 vdd_1v2.n154 vdd_1v2.t0 0.469575
R831 vdd_1v2.t0 vdd_1v2.n7 0.407593
R832 vdd_1v2.t0 vdd_1v2.n23 0.238833
R833 vdd_1v2.n439 vdd_1v2.t0 0.238833
R834 vdd_1v2.t0 vdd_1v2.n9 0.238833
R835 vdd_1v2.t0 vdd_1v2.n8 0.238833
R836 vdd_1v2.n15 vdd_1v2.n59 0.291281
R837 vdd_1v2.n119 vdd_1v2.n44 0.34382
R838 vdd_1v2.n116 vdd_1v2.t0 0.238833
R839 vdd_1v2.t0 vdd_1v2.n36 0.262024
R840 vdd_1v2.n308 vdd_1v2.t0 0.299543
R841 vdd_1v2.t0 vdd_1v2.n34 0.238833
R842 vdd_1v2.t0 vdd_1v2.n33 0.238833
R843 vdd_1v2.n293 vdd_1v2.t0 0.238833
R844 vdd_1v2.n255 vdd_1v2.t0 0.238833
R845 vdd_1v2.t0 vdd_1v2.n31 0.238833
R846 vdd_1v2.n262 vdd_1v2.t0 0.238833
R847 vdd_1v2.t0 vdd_1v2.n32 0.238833
R848 vdd_1v2.t0 vdd_1v2.n39 0.238833
R849 vdd_1v2.n171 vdd_1v2.t0 0.238833
R850 vdd_1v2.n41 vdd_1v2.n167 0.295081
R851 vdd_1v2.t0 vdd_1v2.n10 0.238833
R852 vdd_1v2.n14 vdd_1v2.n61 0.329742
R853 vdd_1v2.n447 vdd_1v2.n446 0.238833
R854 vdd_1v2.n381 vdd_1v2.n380 0.238833
R855 vdd_1v2.n377 vdd_1v2.n45 0.28938
R856 vdd_1v2.n371 vdd_1v2.t0 0.323683
R857 vdd_1v2.t0 vdd_1v2.n3 0.238833
R858 vdd_1v2.n364 vdd_1v2.t0 0.238833
R859 vdd_1v2.t0 vdd_1v2.n4 0.238833
R860 vdd_1v2.n350 vdd_1v2.t0 0.238833
R861 vdd_1v2.t0 vdd_1v2.n6 0.238833
R862 vdd_1v2.t0 vdd_1v2.n5 0.238833
R863 vdd_1v2.n356 vdd_1v2.t0 0.238833
R864 vdd_1v2.n522 vdd_1v2.t0 0.238833
R865 vdd_1v2.t0 vdd_1v2.n19 0.238833
R866 vdd_1v2.t0 vdd_1v2.n18 0.238833
R867 vdd_1v2.t0 vdd_1v2.n17 0.238833
R868 vdd_1v2.n508 vdd_1v2.t0 0.238833
R869 vdd_1v2.t0 vdd_1v2.n16 0.238833
R870 vdd_1v2.n556 vdd_1v2.t0 0.238833
R871 vdd_1v2.t0 vdd_1v2.n13 0.238833
R872 vdd_1v2.t0 vdd_1v2.n12 0.238833
R873 vdd_1v2.t0 vdd_1v2.n11 0.238833
R874 vdd_1v2.n543 vdd_1v2.t0 0.238833
R875 vdd_1v2.t0 vdd_1v2.n21 0.238833
R876 vdd_1v2.t0 vdd_1v2.n22 0.238833
R877 vdd_1v2.t0 vdd_1v2.n20 0.238833
R878 vdd_1v2.n576 vdd_1v2.t0 0.238833
R879 vdd_1v2.t0 vdd_1v2.n29 0.238833
R880 vdd_1v2.t0 vdd_1v2.n28 0.238833
R881 vdd_1v2.n530 vdd_1v2.t0 0.248331
R882 vdd_1v2.t0 vdd_1v2.n26 0.238833
R883 vdd_1v2.t0 vdd_1v2.n27 0.238833
R884 vdd_1v2.n459 vdd_1v2.t0 0.238833
R885 vdd_1v2.n563 vdd_1v2.t0 0.238833
R886 vdd_1v2.t0 vdd_1v2.n24 0.238833
R887 vdd_1v2.t0 vdd_1v2.n25 0.238833
R888 vdd_1v2.n452 vdd_1v2.t0 0.238833
R889 vdd_1v2.n583 vdd_1v2.t0 0.238833
R890 vdd_1v2.t0 vdd_1v2.n30 0.238833
R891 vdd_1v2.t0 vdd_1v2.n35 0.573419
R892 vdd_1v2.n43 vdd_1v2.n266 1.12953
R893 vdd_1v2.n192 vdd_1v2.t0 2.36913
R894 vdd_1v2.n206 vdd_1v2.t0 2.36924
R895 vdd_1v2.n199 vdd_1v2.t0 2.43334
R896 vdd_1v2.n38 vdd_1v2.n344 0.1941
R897 vdd_1v2.n338 vdd_1v2.n337 0.1941
R898 vdd_1v2.n330 vdd_1v2.n329 0.1941
R899 vdd_1v2.n323 vdd_1v2.t0 0.1941
R900 vdd_1v2.n477 vdd_1v2.n476 0.1941
R901 vdd_1v2.n484 vdd_1v2.n483 0.1941
R902 vdd_1v2.n492 vdd_1v2.n491 0.1941
R903 vdd_1v2.t0 vdd_1v2.n2 0.1941
R904 vdd_1v2.t0 vdd_1v2.n38 0.243385
R905 vdd_1v2.n23 vdd_1v2.n441 0.161833
R906 vdd_1v2.n441 vdd_1v2.n436 0.161833
R907 vdd_1v2.n440 vdd_1v2.n439 0.161833
R908 vdd_1v2.n440 vdd_1v2.n438 0.161833
R909 vdd_1v2.n9 vdd_1v2.n524 0.161833
R910 vdd_1v2.n524 vdd_1v2.n519 0.161833
R911 vdd_1v2.n517 vdd_1v2.n512 0.161833
R912 vdd_1v2.n8 vdd_1v2.n517 0.161833
R913 vdd_1v2.n516 vdd_1v2.n515 0.161833
R914 vdd_1v2.n516 vdd_1v2.n513 0.161833
R915 vdd_1v2.n301 vdd_1v2.n300 0.161833
R916 vdd_1v2.n301 vdd_1v2.n298 0.161833
R917 vdd_1v2.n302 vdd_1v2.n297 0.161833
R918 vdd_1v2.n59 vdd_1v2.n302 0.161833
R919 vdd_1v2.n164 vdd_1v2.n163 0.161833
R920 vdd_1v2.n163 vdd_1v2.n162 0.161833
R921 vdd_1v2.n166 vdd_1v2.n159 0.161833
R922 vdd_1v2.n161 vdd_1v2.n159 0.161833
R923 vdd_1v2.n282 vdd_1v2.n281 0.161833
R924 vdd_1v2.n281 vdd_1v2.n35 0.161833
R925 vdd_1v2.n246 vdd_1v2.n245 0.161833
R926 vdd_1v2.n247 vdd_1v2.n246 0.161833
R927 vdd_1v2.n277 vdd_1v2.n272 0.161833
R928 vdd_1v2.n278 vdd_1v2.n277 0.161833
R929 vdd_1v2.n276 vdd_1v2.n275 0.161833
R930 vdd_1v2.n276 vdd_1v2.n273 0.161833
R931 vdd_1v2.n181 vdd_1v2.n180 0.161833
R932 vdd_1v2.n180 vdd_1v2.n179 0.161833
R933 vdd_1v2.n56 vdd_1v2.n176 0.161833
R934 vdd_1v2.n178 vdd_1v2.n176 0.161833
R935 vdd_1v2.n269 vdd_1v2.n268 0.161833
R936 vdd_1v2.n269 vdd_1v2.n266 0.161833
R937 vdd_1v2.n270 vdd_1v2.n265 0.161833
R938 vdd_1v2.n37 vdd_1v2.n270 0.161833
R939 vdd_1v2.n288 vdd_1v2.n287 0.161833
R940 vdd_1v2.n287 vdd_1v2.n286 0.161833
R941 vdd_1v2.t103 vdd_1v2.t106 0.161833
R942 vdd_1v2.n143 vdd_1v2.t106 0.161833
R943 vdd_1v2.t107 vdd_1v2.n143 0.161833
R944 vdd_1v2.n148 vdd_1v2.t107 0.161833
R945 vdd_1v2.n148 vdd_1v2.t117 0.161833
R946 vdd_1v2.n139 vdd_1v2.t117 0.161833
R947 vdd_1v2.t120 vdd_1v2.n139 0.161833
R948 vdd_1v2.n150 vdd_1v2.t120 0.161833
R949 vdd_1v2.n150 vdd_1v2.t123 0.161833
R950 vdd_1v2.n0 vdd_1v2.t123 0.161833
R951 vdd_1v2.t0 vdd_1v2.n0 0.161833
R952 vdd_1v2.n145 vdd_1v2.n144 0.161833
R953 vdd_1v2.n147 vdd_1v2.n145 0.161833
R954 vdd_1v2.n147 vdd_1v2.n142 0.161833
R955 vdd_1v2.n140 vdd_1v2.n142 0.161833
R956 vdd_1v2.n141 vdd_1v2.n140 0.161833
R957 vdd_1v2.n149 vdd_1v2.n141 0.161833
R958 vdd_1v2.n149 vdd_1v2.n138 0.161833
R959 vdd_1v2.n136 vdd_1v2.n138 0.161833
R960 vdd_1v2.n137 vdd_1v2.n136 0.161833
R961 vdd_1v2.n151 vdd_1v2.n137 0.161833
R962 vdd_1v2.n40 vdd_1v2.t126 7.55693
R963 vdd_1v2.t71 vdd_1v2.t68 0.161833
R964 vdd_1v2.n131 vdd_1v2.t71 0.161833
R965 vdd_1v2.n131 vdd_1v2.t74 0.161833
R966 vdd_1v2.n125 vdd_1v2.t74 0.161833
R967 vdd_1v2.t77 vdd_1v2.n125 0.161833
R968 vdd_1v2.n133 vdd_1v2.t77 0.161833
R969 vdd_1v2.n133 vdd_1v2.t80 0.161833
R970 vdd_1v2.n121 vdd_1v2.t80 0.161833
R971 vdd_1v2.t83 vdd_1v2.n121 0.161833
R972 vdd_1v2.n135 vdd_1v2.t83 0.161833
R973 vdd_1v2.n135 vdd_1v2.t86 0.161833
R974 vdd_1v2.n130 vdd_1v2.n128 0.161833
R975 vdd_1v2.n126 vdd_1v2.n128 0.161833
R976 vdd_1v2.n127 vdd_1v2.n126 0.161833
R977 vdd_1v2.n132 vdd_1v2.n127 0.161833
R978 vdd_1v2.n132 vdd_1v2.n124 0.161833
R979 vdd_1v2.n122 vdd_1v2.n124 0.161833
R980 vdd_1v2.n123 vdd_1v2.n122 0.161833
R981 vdd_1v2.n134 vdd_1v2.n123 0.161833
R982 vdd_1v2.n134 vdd_1v2.n120 0.161833
R983 vdd_1v2.n118 vdd_1v2.n120 0.161833
R984 vdd_1v2.n119 vdd_1v2.n118 0.161833
R985 vdd_1v2.n78 vdd_1v2.t42 0.161833
R986 vdd_1v2.t42 vdd_1v2.n64 0.161833
R987 vdd_1v2.n64 vdd_1v2.t45 0.161833
R988 vdd_1v2.n76 vdd_1v2.t45 0.161833
R989 vdd_1v2.n76 vdd_1v2.t48 0.161833
R990 vdd_1v2.t48 vdd_1v2.n68 0.161833
R991 vdd_1v2.n68 vdd_1v2.t51 0.161833
R992 vdd_1v2.n74 vdd_1v2.t51 0.161833
R993 vdd_1v2.n74 vdd_1v2.t54 0.161833
R994 vdd_1v2.t54 vdd_1v2.t57 0.161833
R995 vdd_1v2.n42 vdd_1v2.n62 0.395037
R996 vdd_1v2.n62 vdd_1v2.n63 0.161833
R997 vdd_1v2.n77 vdd_1v2.n63 0.161833
R998 vdd_1v2.n77 vdd_1v2.n66 0.161833
R999 vdd_1v2.n66 vdd_1v2.n65 0.161833
R1000 vdd_1v2.n65 vdd_1v2.n67 0.161833
R1001 vdd_1v2.n75 vdd_1v2.n67 0.161833
R1002 vdd_1v2.n75 vdd_1v2.n70 0.161833
R1003 vdd_1v2.n70 vdd_1v2.n69 0.161833
R1004 vdd_1v2.n69 vdd_1v2.n71 0.161833
R1005 vdd_1v2.n73 vdd_1v2.n71 0.161833
R1006 vdd_1v2.n116 vdd_1v2.n115 0.161833
R1007 vdd_1v2.n115 vdd_1v2.n114 0.161833
R1008 vdd_1v2.n114 vdd_1v2.n113 0.161833
R1009 vdd_1v2.n113 vdd_1v2.n83 0.161833
R1010 vdd_1v2.n108 vdd_1v2.n83 0.161833
R1011 vdd_1v2.n108 vdd_1v2.n107 0.161833
R1012 vdd_1v2.n107 vdd_1v2.n106 0.161833
R1013 vdd_1v2.n106 vdd_1v2.n87 0.161833
R1014 vdd_1v2.n102 vdd_1v2.n87 0.161833
R1015 vdd_1v2.n102 vdd_1v2.n101 0.161833
R1016 vdd_1v2.n101 vdd_1v2.n100 0.161833
R1017 vdd_1v2.n100 vdd_1v2.n91 0.161833
R1018 vdd_1v2.n96 vdd_1v2.n91 0.161833
R1019 vdd_1v2.n96 vdd_1v2.n95 0.161833
R1020 vdd_1v2.n36 vdd_1v2.n81 0.161833
R1021 vdd_1v2.n111 vdd_1v2.n81 0.161833
R1022 vdd_1v2.n112 vdd_1v2.n111 0.161833
R1023 vdd_1v2.n112 vdd_1v2.n110 0.161833
R1024 vdd_1v2.n110 vdd_1v2.n109 0.161833
R1025 vdd_1v2.n109 vdd_1v2.n85 0.161833
R1026 vdd_1v2.n105 vdd_1v2.n85 0.161833
R1027 vdd_1v2.n105 vdd_1v2.n104 0.161833
R1028 vdd_1v2.n104 vdd_1v2.n103 0.161833
R1029 vdd_1v2.n103 vdd_1v2.n89 0.161833
R1030 vdd_1v2.n99 vdd_1v2.n89 0.161833
R1031 vdd_1v2.n99 vdd_1v2.n98 0.161833
R1032 vdd_1v2.n98 vdd_1v2.n97 0.161833
R1033 vdd_1v2.n97 vdd_1v2.n93 0.161833
R1034 vdd_1v2.n308 vdd_1v2.n307 0.161833
R1035 vdd_1v2.n307 vdd_1v2.n306 0.161833
R1036 vdd_1v2.n34 vdd_1v2.n303 0.161833
R1037 vdd_1v2.n305 vdd_1v2.n303 0.161833
R1038 vdd_1v2.n33 vdd_1v2.n295 0.161833
R1039 vdd_1v2.n295 vdd_1v2.n290 0.161833
R1040 vdd_1v2.n294 vdd_1v2.n293 0.161833
R1041 vdd_1v2.n294 vdd_1v2.n292 0.161833
R1042 vdd_1v2.n255 vdd_1v2.n254 0.161833
R1043 vdd_1v2.n254 vdd_1v2.n253 0.161833
R1044 vdd_1v2.n31 vdd_1v2.n250 0.161833
R1045 vdd_1v2.n252 vdd_1v2.n250 0.161833
R1046 vdd_1v2.n262 vdd_1v2.n261 0.161833
R1047 vdd_1v2.n261 vdd_1v2.n260 0.161833
R1048 vdd_1v2.n32 vdd_1v2.n257 0.161833
R1049 vdd_1v2.n259 vdd_1v2.n257 0.161833
R1050 vdd_1v2.t206 vdd_1v2.t203 0.161833
R1051 vdd_1v2.n175 vdd_1v2.n170 0.161833
R1052 vdd_1v2.n39 vdd_1v2.n175 0.161833
R1053 vdd_1v2.n174 vdd_1v2.n173 0.161833
R1054 vdd_1v2.n174 vdd_1v2.n171 0.161833
R1055 vdd_1v2.t0 vdd_1v2.n1 0.161833
R1056 vdd_1v2.n158 vdd_1v2.n153 0.161833
R1057 vdd_1v2.n10 vdd_1v2.n158 0.161833
R1058 vdd_1v2.n157 vdd_1v2.n156 0.161833
R1059 vdd_1v2.n157 vdd_1v2.n154 0.161833
R1060 vdd_1v2.n61 vdd_1v2.n449 0.161833
R1061 vdd_1v2.n449 vdd_1v2.n443 0.161833
R1062 vdd_1v2.n448 vdd_1v2.n447 0.161833
R1063 vdd_1v2.n448 vdd_1v2.n445 0.161833
R1064 vdd_1v2.n380 vdd_1v2.n379 0.161833
R1065 vdd_1v2.n379 vdd_1v2.n374 0.161833
R1066 vdd_1v2.n378 vdd_1v2.n377 0.161833
R1067 vdd_1v2.n378 vdd_1v2.n376 0.161833
R1068 vdd_1v2.n371 vdd_1v2.n370 0.161833
R1069 vdd_1v2.n370 vdd_1v2.n369 0.161833
R1070 vdd_1v2.n3 vdd_1v2.n366 0.161833
R1071 vdd_1v2.n368 vdd_1v2.n366 0.161833
R1072 vdd_1v2.n364 vdd_1v2.n363 0.161833
R1073 vdd_1v2.n363 vdd_1v2.n362 0.161833
R1074 vdd_1v2.n4 vdd_1v2.n359 0.161833
R1075 vdd_1v2.n361 vdd_1v2.n359 0.161833
R1076 vdd_1v2.n350 vdd_1v2.n349 0.161833
R1077 vdd_1v2.n349 vdd_1v2.n348 0.161833
R1078 vdd_1v2.n6 vdd_1v2.n345 0.161833
R1079 vdd_1v2.n347 vdd_1v2.n345 0.161833
R1080 vdd_1v2.n5 vdd_1v2.n358 0.161833
R1081 vdd_1v2.n358 vdd_1v2.n353 0.161833
R1082 vdd_1v2.n357 vdd_1v2.n356 0.161833
R1083 vdd_1v2.n357 vdd_1v2.n355 0.161833
R1084 vdd_1v2.n523 vdd_1v2.n522 0.161833
R1085 vdd_1v2.n523 vdd_1v2.n521 0.161833
R1086 vdd_1v2.n19 vdd_1v2.n510 0.161833
R1087 vdd_1v2.n510 vdd_1v2.n499 0.161833
R1088 vdd_1v2.n505 vdd_1v2.n504 0.161833
R1089 vdd_1v2.n505 vdd_1v2.n18 0.161833
R1090 vdd_1v2.n506 vdd_1v2.n502 0.161833
R1091 vdd_1v2.n17 vdd_1v2.n506 0.161833
R1092 vdd_1v2.n509 vdd_1v2.n508 0.161833
R1093 vdd_1v2.n509 vdd_1v2.n501 0.161833
R1094 vdd_1v2.n16 vdd_1v2.n551 0.161833
R1095 vdd_1v2.n551 vdd_1v2.n547 0.161833
R1096 vdd_1v2.n555 vdd_1v2.n554 0.161833
R1097 vdd_1v2.n556 vdd_1v2.n555 0.161833
R1098 vdd_1v2.n553 vdd_1v2.n545 0.161833
R1099 vdd_1v2.n13 vdd_1v2.n545 0.161833
R1100 vdd_1v2.n550 vdd_1v2.n12 0.161833
R1101 vdd_1v2.n550 vdd_1v2.n549 0.161833
R1102 vdd_1v2.n11 vdd_1v2.n538 0.161833
R1103 vdd_1v2.n538 vdd_1v2.n534 0.161833
R1104 vdd_1v2.n542 vdd_1v2.n541 0.161833
R1105 vdd_1v2.n543 vdd_1v2.n542 0.161833
R1106 vdd_1v2.n540 vdd_1v2.n532 0.161833
R1107 vdd_1v2.n21 vdd_1v2.n532 0.161833
R1108 vdd_1v2.n537 vdd_1v2.n22 0.161833
R1109 vdd_1v2.n537 vdd_1v2.n536 0.161833
R1110 vdd_1v2.n20 vdd_1v2.n571 0.161833
R1111 vdd_1v2.n571 vdd_1v2.n567 0.161833
R1112 vdd_1v2.n575 vdd_1v2.n574 0.161833
R1113 vdd_1v2.n576 vdd_1v2.n575 0.161833
R1114 vdd_1v2.n573 vdd_1v2.n565 0.161833
R1115 vdd_1v2.n29 vdd_1v2.n565 0.161833
R1116 vdd_1v2.n570 vdd_1v2.n28 0.161833
R1117 vdd_1v2.n570 vdd_1v2.n569 0.161833
R1118 vdd_1v2.n529 vdd_1v2.n528 0.161833
R1119 vdd_1v2.n530 vdd_1v2.n529 0.161833
R1120 vdd_1v2.n527 vdd_1v2.n525 0.161833
R1121 vdd_1v2.n26 vdd_1v2.n525 0.161833
R1122 vdd_1v2.n463 vdd_1v2.n458 0.161833
R1123 vdd_1v2.n27 vdd_1v2.n463 0.161833
R1124 vdd_1v2.n462 vdd_1v2.n461 0.161833
R1125 vdd_1v2.n462 vdd_1v2.n459 0.161833
R1126 vdd_1v2.n562 vdd_1v2.n561 0.161833
R1127 vdd_1v2.n563 vdd_1v2.n562 0.161833
R1128 vdd_1v2.n560 vdd_1v2.n558 0.161833
R1129 vdd_1v2.n24 vdd_1v2.n558 0.161833
R1130 vdd_1v2.n456 vdd_1v2.n451 0.161833
R1131 vdd_1v2.n25 vdd_1v2.n456 0.161833
R1132 vdd_1v2.n455 vdd_1v2.n454 0.161833
R1133 vdd_1v2.n455 vdd_1v2.n452 0.161833
R1134 vdd_1v2.n582 vdd_1v2.n581 0.161833
R1135 vdd_1v2.n583 vdd_1v2.n582 0.161833
R1136 vdd_1v2.n580 vdd_1v2.n578 0.161833
R1137 vdd_1v2.n30 vdd_1v2.n578 0.161833
R1138 vdd_1v2.n208 vdd_1v2.n207 0.146155
R1139 vdd_1v2.n208 vdd_1v2.n183 0.146155
R1140 vdd_1v2.n212 vdd_1v2.n183 0.146155
R1141 vdd_1v2.n201 vdd_1v2.n200 0.146155
R1142 vdd_1v2.n201 vdd_1v2.n186 0.146155
R1143 vdd_1v2.n205 vdd_1v2.n186 0.146155
R1144 vdd_1v2.n194 vdd_1v2.n193 0.146155
R1145 vdd_1v2.n194 vdd_1v2.n189 0.146155
R1146 vdd_1v2.n198 vdd_1v2.n189 0.146155
R1147 vdd_1v2.n229 vdd_1v2.n228 0.146155
R1148 vdd_1v2.n229 vdd_1v2.n216 0.146155
R1149 vdd_1v2.n233 vdd_1v2.n216 0.146155
R1150 vdd_1v2.n223 vdd_1v2.n222 0.146155
R1151 vdd_1v2.n223 vdd_1v2.n219 0.146155
R1152 vdd_1v2.n227 vdd_1v2.n219 0.146155
R1153 vdd_1v2.n236 vdd_1v2.n235 0.146155
R1154 vdd_1v2.n236 vdd_1v2.n213 0.146155
R1155 vdd_1v2.n240 vdd_1v2.n213 0.146155
R1156 vdd_1v2.n431 vdd_1v2.n411 0.146155
R1157 vdd_1v2.n427 vdd_1v2.n411 0.146155
R1158 vdd_1v2.n428 vdd_1v2.n427 0.146155
R1159 vdd_1v2.n422 vdd_1v2.n420 0.146155
R1160 vdd_1v2.n420 vdd_1v2.n416 0.146155
R1161 vdd_1v2.n425 vdd_1v2.n416 0.146155
R1162 vdd_1v2.n396 vdd_1v2.n395 0.146155
R1163 vdd_1v2.n395 vdd_1v2.n391 0.146155
R1164 vdd_1v2.n399 vdd_1v2.n391 0.146155
R1165 vdd_1v2.n386 vdd_1v2.n385 0.146155
R1166 vdd_1v2.n386 vdd_1v2.n382 0.146155
R1167 vdd_1v2.n390 vdd_1v2.n382 0.146155
R1168 vdd_1v2.n634 vdd_1v2.n614 0.146155
R1169 vdd_1v2.n630 vdd_1v2.n614 0.146155
R1170 vdd_1v2.n631 vdd_1v2.n630 0.146155
R1171 vdd_1v2.n625 vdd_1v2.n623 0.146155
R1172 vdd_1v2.n623 vdd_1v2.n619 0.146155
R1173 vdd_1v2.n628 vdd_1v2.n619 0.146155
R1174 vdd_1v2.n599 vdd_1v2.n598 0.146155
R1175 vdd_1v2.n598 vdd_1v2.n594 0.146155
R1176 vdd_1v2.n602 vdd_1v2.n594 0.146155
R1177 vdd_1v2.n589 vdd_1v2.n588 0.146155
R1178 vdd_1v2.n589 vdd_1v2.n585 0.146155
R1179 vdd_1v2.n593 vdd_1v2.n585 0.146155
R1180 vdd_1v2.n224 vdd_1v2.n221 0.143082
R1181 vdd_1v2.n226 vdd_1v2.n220 0.143082
R1182 vdd_1v2.n230 vdd_1v2.n218 0.143082
R1183 vdd_1v2.n232 vdd_1v2.n217 0.143082
R1184 vdd_1v2.n237 vdd_1v2.n215 0.143082
R1185 vdd_1v2.n239 vdd_1v2.n214 0.143082
R1186 vdd_1v2.n195 vdd_1v2.n191 0.143082
R1187 vdd_1v2.n197 vdd_1v2.n190 0.143082
R1188 vdd_1v2.n202 vdd_1v2.n188 0.143082
R1189 vdd_1v2.n204 vdd_1v2.n187 0.143082
R1190 vdd_1v2.n209 vdd_1v2.n185 0.143082
R1191 vdd_1v2.n211 vdd_1v2.n184 0.143082
R1192 vdd_1v2.n423 vdd_1v2.n419 0.143082
R1193 vdd_1v2.n424 vdd_1v2.n417 0.143082
R1194 vdd_1v2.n430 vdd_1v2.n412 0.143082
R1195 vdd_1v2.n429 vdd_1v2.n414 0.143082
R1196 vdd_1v2.n397 vdd_1v2.n394 0.143082
R1197 vdd_1v2.n398 vdd_1v2.n392 0.143082
R1198 vdd_1v2.n387 vdd_1v2.n384 0.143082
R1199 vdd_1v2.n389 vdd_1v2.n383 0.143082
R1200 vdd_1v2.n626 vdd_1v2.n622 0.143082
R1201 vdd_1v2.n627 vdd_1v2.n620 0.143082
R1202 vdd_1v2.n633 vdd_1v2.n615 0.143082
R1203 vdd_1v2.n632 vdd_1v2.n617 0.143082
R1204 vdd_1v2.n600 vdd_1v2.n597 0.143082
R1205 vdd_1v2.n601 vdd_1v2.n595 0.143082
R1206 vdd_1v2.n590 vdd_1v2.n587 0.143082
R1207 vdd_1v2.n592 vdd_1v2.n586 0.143082
R1208 vdd_1v2.t0 vdd_1v2.t407 17.6239
R1209 vdd_1v2.n78 vdd_1v2.t0 1.12881
R1210 vdd_1v2.n41 vdd_1v2.t0 1.1266
R1211 vdd_1v2.n337 vdd_1v2.n336 0.1325
R1212 vdd_1v2.n331 vdd_1v2.n330 0.1325
R1213 vdd_1v2.n485 vdd_1v2.n484 0.1325
R1214 vdd_1v2.n491 vdd_1v2.n490 0.1325
R1215 vdd_1v2.n60 vdd_1v2.n381 0.209739
R1216 vdd_1v2.n225 vdd_1v2.n224 0.0917908
R1217 vdd_1v2.n225 vdd_1v2.n220 0.0917908
R1218 vdd_1v2.n231 vdd_1v2.n230 0.0917908
R1219 vdd_1v2.n231 vdd_1v2.n217 0.0917908
R1220 vdd_1v2.n238 vdd_1v2.n237 0.0917908
R1221 vdd_1v2.n238 vdd_1v2.n214 0.0917908
R1222 vdd_1v2.n196 vdd_1v2.n195 0.0917908
R1223 vdd_1v2.n196 vdd_1v2.n190 0.0917908
R1224 vdd_1v2.n203 vdd_1v2.n202 0.0917908
R1225 vdd_1v2.n203 vdd_1v2.n187 0.0917908
R1226 vdd_1v2.n210 vdd_1v2.n209 0.0917908
R1227 vdd_1v2.n210 vdd_1v2.n184 0.0917908
R1228 vdd_1v2.n419 vdd_1v2.n418 0.0917908
R1229 vdd_1v2.n418 vdd_1v2.n417 0.0917908
R1230 vdd_1v2.n413 vdd_1v2.n412 0.0917908
R1231 vdd_1v2.n414 vdd_1v2.n413 0.0917908
R1232 vdd_1v2.n394 vdd_1v2.n393 0.0917908
R1233 vdd_1v2.n393 vdd_1v2.n392 0.0917908
R1234 vdd_1v2.n388 vdd_1v2.n387 0.0917908
R1235 vdd_1v2.n388 vdd_1v2.n383 0.0917908
R1236 vdd_1v2.n622 vdd_1v2.n621 0.0917908
R1237 vdd_1v2.n621 vdd_1v2.n620 0.0917908
R1238 vdd_1v2.n616 vdd_1v2.n615 0.0917908
R1239 vdd_1v2.n617 vdd_1v2.n616 0.0917908
R1240 vdd_1v2.n597 vdd_1v2.n596 0.0917908
R1241 vdd_1v2.n596 vdd_1v2.n595 0.0917908
R1242 vdd_1v2.n591 vdd_1v2.n590 0.0917908
R1243 vdd_1v2.n591 vdd_1v2.n586 0.0917908
R1244 vdd_1v2.n513 vdd_1v2.t0 0.27785
R1245 vdd_1v2.t0 vdd_1v2.n15 0.327255
R1246 vdd_1v2.n344 vdd_1v2.n343 0.075841
R1247 vdd_1v2.n340 vdd_1v2.n338 0.075841
R1248 vdd_1v2.n329 vdd_1v2.n328 0.075841
R1249 vdd_1v2.n325 vdd_1v2.n323 0.075841
R1250 vdd_1v2.n479 vdd_1v2.n477 0.075841
R1251 vdd_1v2.n483 vdd_1v2.n482 0.075841
R1252 vdd_1v2.n494 vdd_1v2.n492 0.075841
R1253 vdd_1v2.n2 vdd_1v2.n497 0.075841
R1254 vdd_1v2.n315 vdd_1v2.n314 0.0638256
R1255 vdd_1v2.n341 vdd_1v2.n312 0.0638256
R1256 vdd_1v2.n321 vdd_1v2.n320 0.0638256
R1257 vdd_1v2.n326 vdd_1v2.n318 0.0638256
R1258 vdd_1v2.n474 vdd_1v2.n473 0.0638256
R1259 vdd_1v2.n480 vdd_1v2.n471 0.0638256
R1260 vdd_1v2.n468 vdd_1v2.n467 0.0638256
R1261 vdd_1v2.n495 vdd_1v2.n465 0.0638256
R1262 vdd_1v2.n339 vdd_1v2.n316 0.0619802
R1263 vdd_1v2.n324 vdd_1v2.n322 0.0619802
R1264 vdd_1v2.n478 vdd_1v2.n475 0.0619802
R1265 vdd_1v2.n493 vdd_1v2.n469 0.0619802
R1266 vdd_1v2.n342 vdd_1v2.n311 0.0616443
R1267 vdd_1v2.n327 vdd_1v2.n317 0.0616443
R1268 vdd_1v2.n481 vdd_1v2.n470 0.0616443
R1269 vdd_1v2.n496 vdd_1v2.n464 0.0616443
R1270 vdd_1v2.n50 vdd_1v2.n298 0.713973
R1271 vdd_1v2.n55 vdd_1v2.t0 0.182079
R1272 vdd_1v2.n340 vdd_1v2.n339 0.0493201
R1273 vdd_1v2.n343 vdd_1v2.n311 0.0493201
R1274 vdd_1v2.n325 vdd_1v2.n324 0.0493201
R1275 vdd_1v2.n328 vdd_1v2.n317 0.0493201
R1276 vdd_1v2.n479 vdd_1v2.n478 0.0493201
R1277 vdd_1v2.n482 vdd_1v2.n470 0.0493201
R1278 vdd_1v2.n494 vdd_1v2.n493 0.0493201
R1279 vdd_1v2.n497 vdd_1v2.n464 0.0493201
R1280 vdd_1v2.n310 vdd_1v2.n15 0.455754
R1281 vdd_1v2.n342 vdd_1v2.n341 0.0474747
R1282 vdd_1v2.n327 vdd_1v2.n326 0.0474747
R1283 vdd_1v2.n481 vdd_1v2.n480 0.0474747
R1284 vdd_1v2.n496 vdd_1v2.n495 0.0474747
R1285 vdd_1v2.n316 vdd_1v2.n315 0.0471388
R1286 vdd_1v2.n322 vdd_1v2.n321 0.0471388
R1287 vdd_1v2.n475 vdd_1v2.n474 0.0471388
R1288 vdd_1v2.n469 vdd_1v2.n468 0.0471388
R1289 vdd_1v2.n314 vdd_1v2.n313 0.044485
R1290 vdd_1v2.n313 vdd_1v2.n312 0.044485
R1291 vdd_1v2.n320 vdd_1v2.n319 0.044485
R1292 vdd_1v2.n319 vdd_1v2.n318 0.044485
R1293 vdd_1v2.n473 vdd_1v2.n472 0.044485
R1294 vdd_1v2.n472 vdd_1v2.n471 0.044485
R1295 vdd_1v2.n467 vdd_1v2.n466 0.044485
R1296 vdd_1v2.n466 vdd_1v2.n465 0.044485
R1297 vdd_1v2.n43 vdd_1v2.n47 0.734285
R1298 vdd_1v2.t0 vdd_1v2.n45 1.10912
R1299 vdd_1v2.n42 vdd_1v2.t0 1.103
R1300 vdd_1v2.n43 vdd_1v2.t0 0.209379
R1301 vdd_1v2.n476 vdd_1v2.t0 1.06171
R1302 vdd_1v2.t0 vdd_1v2.n40 0.465431
R1303 vdd_1v2.t0 vdd_1v2.t86 1.03257
R1304 vss_1v2.t15 vss_1v2.n1906 159621
R1305 vss_1v2.n2914 vss_1v2.n1907 76057.1
R1306 vss_1v2.n2914 vss_1v2.n1906 58610.5
R1307 vss_1v2.t43 vss_1v2.t32 38497.2
R1308 vss_1v2.n80 vss_1v2.n1996 23438.5
R1309 vss_1v2.t36 vss_1v2.n266 1939.48
R1310 vss_1v2.t37 vss_1v2.t36 1636.36
R1311 vss_1v2.t323 vss_1v2.t37 1636.36
R1312 vss_1v2.t7 vss_1v2.t323 1636.36
R1313 vss_1v2.t10 vss_1v2.t7 1177.69
R1314 vss_1v2.t32 vss_1v2.t16 477.973
R1315 vss_1v2.t13 vss_1v2.t14 475.39
R1316 vss_1v2.t14 vss_1v2.t15 475.39
R1317 vss_1v2.t16 vss_1v2.t8 380.205
R1318 vss_1v2.n1908 vss_1v2.t13 376.351
R1319 vss_1v2.n1908 vss_1v2.t43 99.0401
R1320 vss_1v2.n4081 vss_1v2.n4094 63.3632
R1321 vss_1v2.n3112 vss_1v2.n3111 60.8427
R1322 vss_1v2.n3108 vss_1v2.t163 59.7916
R1323 vss_1v2.n263 vss_1v2.t41 34.4259
R1324 vss_1v2.n3110 vss_1v2.n3108 30.0768
R1325 vss_1v2.n3108 vss_1v2.n3107 29.99
R1326 vss_1v2.t134 vss_1v2.n3204 27.9576
R1327 vss_1v2.t74 vss_1v2.n4069 26.8832
R1328 vss_1v2.n3204 vss_1v2.t145 26.0005
R1329 vss_1v2.n4068 vss_1v2.t87 26.0005
R1330 vss_1v2.t167 vss_1v2.t171 24.285
R1331 vss_1v2.t232 vss_1v2.t228 24.285
R1332 vss_1v2.n488 vss_1v2.n32 0.00304506
R1333 vss_1v2.t311 vss_1v2.n4076 19.9573
R1334 vss_1v2.n4087 vss_1v2.t10 19.3588
R1335 vss_1v2.n4110 vss_1v2.t34 19.1409
R1336 vss_1v2.n3204 vss_1v2.t320 18.585
R1337 vss_1v2.n4068 vss_1v2.n4050 18.585
R1338 vss_1v2.n2856 vss_1v2.n1985 17.001
R1339 vss_1v2.n436 vss_1v2.n18 2.21442
R1340 vss_1v2.n3191 vss_1v2.n435 17.0005
R1341 vss_1v2.n3191 vss_1v2.n1009 17.0005
R1342 vss_1v2.n4135 vss_1v2.n435 17.0005
R1343 vss_1v2.n4135 vss_1v2.n1010 17.0005
R1344 vss_1v2.n4135 vss_1v2.n1009 17.0005
R1345 vss_1v2.n4135 vss_1v2.n950 17.0005
R1346 vss_1v2.n3320 vss_1v2.n2660 17.0005
R1347 vss_1v2.n3320 vss_1v2.t12 17.0005
R1348 vss_1v2.n4133 vss_1v2.n950 17.0005
R1349 vss_1v2.n4133 vss_1v2.n1271 17.0005
R1350 vss_1v2.n3236 vss_1v2.n3222 17.0005
R1351 vss_1v2.n3237 vss_1v2.n3236 17.0005
R1352 vss_1v2.n3229 vss_1v2.n3218 17.0005
R1353 vss_1v2.n3229 vss_1v2.n3228 17.0005
R1354 vss_1v2.n3136 vss_1v2.n2985 17.0005
R1355 vss_1v2.n3132 vss_1v2.n3136 17.0005
R1356 vss_1v2.n3140 vss_1v2.n2990 17.0005
R1357 vss_1v2.n3141 vss_1v2.n3140 17.0005
R1358 vss_1v2.n351 vss_1v2.n2828 17.0005
R1359 vss_1v2.n2892 vss_1v2.n2888 17.0005
R1360 vss_1v2.n2893 vss_1v2.n2892 17.0005
R1361 vss_1v2.n3092 vss_1v2.n2885 17.0005
R1362 vss_1v2.n3086 vss_1v2.n3092 17.0005
R1363 vss_1v2.n3577 vss_1v2.n3576 17.0005
R1364 vss_1v2.n3577 vss_1v2.n2686 17.0005
R1365 vss_1v2.n2824 vss_1v2.n2823 17.0005
R1366 vss_1v2.n2824 vss_1v2.n2820 17.0005
R1367 vss_1v2.n406 vss_1v2.n1965 17.0005
R1368 vss_1v2.n1302 vss_1v2.n1301 17.0005
R1369 vss_1v2.n2846 vss_1v2.n1979 17.0005
R1370 vss_1v2.n2846 vss_1v2.n2845 17.0005
R1371 vss_1v2.n3540 vss_1v2.n3539 17.0005
R1372 vss_1v2.n3541 vss_1v2.n3540 17.0005
R1373 vss_1v2.n3546 vss_1v2.n3545 17.0005
R1374 vss_1v2.n3547 vss_1v2.n3546 17.0005
R1375 vss_1v2.n3556 vss_1v2.n3553 17.0005
R1376 vss_1v2.n418 vss_1v2.n933 17.0005
R1377 vss_1v2.n3508 vss_1v2.n933 17.0005
R1378 vss_1v2.n3511 vss_1v2.n933 17.0005
R1379 vss_1v2.n3513 vss_1v2.n933 17.0005
R1380 vss_1v2.n3515 vss_1v2.n933 17.0005
R1381 vss_1v2.n3518 vss_1v2.n933 17.0005
R1382 vss_1v2.n3520 vss_1v2.n933 17.0005
R1383 vss_1v2.n3522 vss_1v2.n933 17.0005
R1384 vss_1v2.n3525 vss_1v2.n933 17.0005
R1385 vss_1v2.n3528 vss_1v2.n933 17.0005
R1386 vss_1v2.n3531 vss_1v2.n933 17.0005
R1387 vss_1v2.n2859 vss_1v2.n933 17.0005
R1388 vss_1v2.n2852 vss_1v2.n933 17.0005
R1389 vss_1v2.n3549 vss_1v2.n933 17.0005
R1390 vss_1v2.n3551 vss_1v2.n933 17.0005
R1391 vss_1v2.n12 vss_1v2.n933 17.0005
R1392 vss_1v2.n418 vss_1v2.n935 17.0005
R1393 vss_1v2.n12 vss_1v2.n935 17.0005
R1394 vss_1v2.n4022 vss_1v2.n1988 17.0005
R1395 vss_1v2.n4022 vss_1v2.n1991 17.0005
R1396 vss_1v2.n4022 vss_1v2.n1989 17.0005
R1397 vss_1v2.n4022 vss_1v2.n1990 17.0005
R1398 vss_1v2.n3569 vss_1v2.n462 17.0005
R1399 vss_1v2.n3585 vss_1v2.n457 17.0005
R1400 vss_1v2.n3585 vss_1v2.n303 17.0005
R1401 vss_1v2.n3488 vss_1v2.n3487 17.0005
R1402 vss_1v2.n3488 vss_1v2.n2867 17.0005
R1403 vss_1v2.n4031 vss_1v2.n4030 17.0005
R1404 vss_1v2.n4031 vss_1v2.n1968 17.0005
R1405 vss_1v2.n3838 vss_1v2.n3837 17.0005
R1406 vss_1v2.n3838 vss_1v2.n2450 17.0005
R1407 vss_1v2.n3838 vss_1v2.n2096 17.0005
R1408 vss_1v2.n3838 vss_1v2.n2451 17.0005
R1409 vss_1v2.n3838 vss_1v2.n2452 17.0005
R1410 vss_1v2.n3838 vss_1v2.n2510 17.0005
R1411 vss_1v2.n3838 vss_1v2.n2453 17.0005
R1412 vss_1v2.n3838 vss_1v2.n2507 17.0005
R1413 vss_1v2.n3838 vss_1v2.n2454 17.0005
R1414 vss_1v2.n3838 vss_1v2.n2505 17.0005
R1415 vss_1v2.n3838 vss_1v2.n2455 17.0005
R1416 vss_1v2.n3838 vss_1v2.n2504 17.0005
R1417 vss_1v2.n3838 vss_1v2.n2456 17.0005
R1418 vss_1v2.n3839 vss_1v2.n3838 17.0005
R1419 vss_1v2.n3838 vss_1v2.n2457 17.0005
R1420 vss_1v2.n3838 vss_1v2.n2503 17.0005
R1421 vss_1v2.n3838 vss_1v2.n2458 17.0005
R1422 vss_1v2.n3838 vss_1v2.n2502 17.0005
R1423 vss_1v2.n3838 vss_1v2.n2459 17.0005
R1424 vss_1v2.n3838 vss_1v2.n2501 17.0005
R1425 vss_1v2.n3838 vss_1v2.n2460 17.0005
R1426 vss_1v2.n3838 vss_1v2.n2499 17.0005
R1427 vss_1v2.n3838 vss_1v2.n2461 17.0005
R1428 vss_1v2.n3838 vss_1v2.n418 17.0005
R1429 vss_1v2.n3837 vss_1v2.n2522 17.0005
R1430 vss_1v2.n2522 vss_1v2.n418 17.0005
R1431 vss_1v2.n4016 vss_1v2.n2096 17.0005
R1432 vss_1v2.n2279 vss_1v2.n2096 17.0005
R1433 vss_1v2.n3815 vss_1v2.n2279 17.0005
R1434 vss_1v2.n4003 vss_1v2.n2355 17.0005
R1435 vss_1v2.n4016 vss_1v2.n2097 17.0005
R1436 vss_1v2.n4016 vss_1v2.n2094 17.0005
R1437 vss_1v2.n4016 vss_1v2.n2098 17.0005
R1438 vss_1v2.n4016 vss_1v2.n459 17.0005
R1439 vss_1v2.n4016 vss_1v2.n460 17.0005
R1440 vss_1v2.n4016 vss_1v2.n378 17.0005
R1441 vss_1v2.n4016 vss_1v2.n2099 17.0005
R1442 vss_1v2.n3361 vss_1v2.n2279 17.0005
R1443 vss_1v2.n4003 vss_1v2.n2363 17.0005
R1444 vss_1v2.n4016 vss_1v2.n2093 17.0005
R1445 vss_1v2.n4016 vss_1v2.n2101 17.0005
R1446 vss_1v2.n4016 vss_1v2.n368 17.0005
R1447 vss_1v2.n4016 vss_1v2.n461 17.0005
R1448 vss_1v2.n4016 vss_1v2.n463 17.0005
R1449 vss_1v2.n4016 vss_1v2.n480 17.0005
R1450 vss_1v2.n4016 vss_1v2.n482 17.0005
R1451 vss_1v2.n4016 vss_1v2.n469 17.0005
R1452 vss_1v2.n4016 vss_1v2.n471 17.0005
R1453 vss_1v2.n3374 vss_1v2.n2279 17.0005
R1454 vss_1v2.n4003 vss_1v2.n472 17.0005
R1455 vss_1v2.n4016 vss_1v2.n2102 17.0005
R1456 vss_1v2.n4016 vss_1v2.n2091 17.0005
R1457 vss_1v2.n4016 vss_1v2.n2103 17.0005
R1458 vss_1v2.n4016 vss_1v2.n2090 17.0005
R1459 vss_1v2.n4016 vss_1v2.n2104 17.0005
R1460 vss_1v2.n4016 vss_1v2.n2089 17.0005
R1461 vss_1v2.n4016 vss_1v2.n466 17.0005
R1462 vss_1v2.n3388 vss_1v2.n2279 17.0005
R1463 vss_1v2.n4003 vss_1v2.n2369 17.0005
R1464 vss_1v2.n4016 vss_1v2.n2088 17.0005
R1465 vss_1v2.n4016 vss_1v2.n2106 17.0005
R1466 vss_1v2.n4016 vss_1v2.n2087 17.0005
R1467 vss_1v2.n4016 vss_1v2.n2107 17.0005
R1468 vss_1v2.n4016 vss_1v2.n2086 17.0005
R1469 vss_1v2.n4016 vss_1v2.n2108 17.0005
R1470 vss_1v2.n4016 vss_1v2.n2085 17.0005
R1471 vss_1v2.n4016 vss_1v2.n2109 17.0005
R1472 vss_1v2.n4016 vss_1v2.n2084 17.0005
R1473 vss_1v2.n2910 vss_1v2.n2279 17.0005
R1474 vss_1v2.n4003 vss_1v2.n2342 17.0005
R1475 vss_1v2.n4016 vss_1v2.n474 17.0005
R1476 vss_1v2.n4016 vss_1v2.n475 17.0005
R1477 vss_1v2.n4016 vss_1v2.n476 17.0005
R1478 vss_1v2.n4016 vss_1v2.n477 17.0005
R1479 vss_1v2.n4016 vss_1v2.n2110 17.0005
R1480 vss_1v2.n4016 vss_1v2.n2082 17.0005
R1481 vss_1v2.n4016 vss_1v2.n2111 17.0005
R1482 vss_1v2.n3397 vss_1v2.n2279 17.0005
R1483 vss_1v2.n4003 vss_1v2.n2375 17.0005
R1484 vss_1v2.n4016 vss_1v2.n2081 17.0005
R1485 vss_1v2.n4016 vss_1v2.n2113 17.0005
R1486 vss_1v2.n4016 vss_1v2.n2080 17.0005
R1487 vss_1v2.n4016 vss_1v2.n451 17.0005
R1488 vss_1v2.n4016 vss_1v2.n453 17.0005
R1489 vss_1v2.n3452 vss_1v2.n2279 17.0005
R1490 vss_1v2.n4003 vss_1v2.n454 17.0005
R1491 vss_1v2.n4016 vss_1v2.n2114 17.0005
R1492 vss_1v2.n4016 vss_1v2.n2078 17.0005
R1493 vss_1v2.n4016 vss_1v2.n2115 17.0005
R1494 vss_1v2.n4016 vss_1v2.n2077 17.0005
R1495 vss_1v2.n4016 vss_1v2.n2116 17.0005
R1496 vss_1v2.n4016 vss_1v2.n2076 17.0005
R1497 vss_1v2.n4016 vss_1v2.n2121 17.0005
R1498 vss_1v2.n4016 vss_1v2.n2075 17.0005
R1499 vss_1v2.n4016 vss_1v2.n2122 17.0005
R1500 vss_1v2.n3465 vss_1v2.n2279 17.0005
R1501 vss_1v2.n4003 vss_1v2.n2382 17.0005
R1502 vss_1v2.n4016 vss_1v2.n2074 17.0005
R1503 vss_1v2.n4016 vss_1v2.n2124 17.0005
R1504 vss_1v2.n4016 vss_1v2.n2073 17.0005
R1505 vss_1v2.n4016 vss_1v2.n2125 17.0005
R1506 vss_1v2.n4016 vss_1v2.n2072 17.0005
R1507 vss_1v2.n4016 vss_1v2.n2126 17.0005
R1508 vss_1v2.n4017 vss_1v2.n4016 17.0005
R1509 vss_1v2.n3842 vss_1v2.n75 0.00205979
R1510 vss_1v2.n3842 vss_1v2.n215 17.0005
R1511 vss_1v2.n3842 vss_1v2.n214 17.0005
R1512 vss_1v2.n3842 vss_1v2.n213 17.0005
R1513 vss_1v2.n370 vss_1v2.n3810 5.66667
R1514 vss_1v2.n371 vss_1v2.n372 5.66778
R1515 vss_1v2.n3810 vss_1v2.n2523 17.0005
R1516 vss_1v2.n481 vss_1v2.n470 17.0005
R1517 vss_1v2.n481 vss_1v2.n464 0.00354514
R1518 vss_1v2.n3455 vss_1v2.n470 17.0005
R1519 vss_1v2.n424 vss_1v2.n465 17.0005
R1520 vss_1v2.n424 vss_1v2.n425 0.643508
R1521 vss_1v2.n3486 vss_1v2.n3485 17.0005
R1522 vss_1v2.n3487 vss_1v2.n3486 17.0005
R1523 vss_1v2.n2929 vss_1v2.n2869 17.0005
R1524 vss_1v2.n3505 vss_1v2.n2869 17.0005
R1525 vss_1v2.n2930 vss_1v2.n1974 17.0005
R1526 vss_1v2.n4030 vss_1v2.n1974 17.0005
R1527 vss_1v2.n2916 vss_1v2.n1968 17.0005
R1528 vss_1v2.n2918 vss_1v2.n1968 17.0005
R1529 vss_1v2.n2921 vss_1v2.n1968 17.0005
R1530 vss_1v2.n2923 vss_1v2.n1968 17.0005
R1531 vss_1v2.n2925 vss_1v2.n1968 17.0005
R1532 vss_1v2.n2927 vss_1v2.n1968 17.0005
R1533 vss_1v2.n4129 vss_1v2.n1856 17.0005
R1534 vss_1v2.n4129 vss_1v2.n1855 17.0005
R1535 vss_1v2.n12 vss_1v2.n717 17.0005
R1536 vss_1v2.n3844 vss_1v2.n2279 17.0005
R1537 vss_1v2.n4003 vss_1v2.n2333 17.0005
R1538 vss_1v2.n4016 vss_1v2.n2128 17.0005
R1539 vss_1v2.n3848 vss_1v2.n2279 17.0005
R1540 vss_1v2.n4003 vss_1v2.n2385 17.0005
R1541 vss_1v2.n4016 vss_1v2.n2070 17.0005
R1542 vss_1v2.n4016 vss_1v2.n2129 17.0005
R1543 vss_1v2.n4016 vss_1v2.n2069 17.0005
R1544 vss_1v2.n4016 vss_1v2.n2130 17.0005
R1545 vss_1v2.n4016 vss_1v2.n2068 17.0005
R1546 vss_1v2.n3856 vss_1v2.n2279 17.0005
R1547 vss_1v2.n4003 vss_1v2.n2328 17.0005
R1548 vss_1v2.n4016 vss_1v2.n2132 17.0005
R1549 vss_1v2.n4016 vss_1v2.n2067 17.0005
R1550 vss_1v2.n4016 vss_1v2.n2133 17.0005
R1551 vss_1v2.n4016 vss_1v2.n2066 17.0005
R1552 vss_1v2.n4016 vss_1v2.n2134 17.0005
R1553 vss_1v2.n4016 vss_1v2.n2065 17.0005
R1554 vss_1v2.n4016 vss_1v2.n2135 17.0005
R1555 vss_1v2.n4016 vss_1v2.n2064 17.0005
R1556 vss_1v2.n4016 vss_1v2.n2136 17.0005
R1557 vss_1v2.n4016 vss_1v2.n2063 17.0005
R1558 vss_1v2.n4016 vss_1v2.n2137 17.0005
R1559 vss_1v2.n4016 vss_1v2.n2062 17.0005
R1560 vss_1v2.n4016 vss_1v2.n2138 17.0005
R1561 vss_1v2.n4016 vss_1v2.n2061 17.0005
R1562 vss_1v2.n4016 vss_1v2.n2139 17.0005
R1563 vss_1v2.n4016 vss_1v2.n2060 17.0005
R1564 vss_1v2.n4016 vss_1v2.n2140 17.0005
R1565 vss_1v2.n4016 vss_1v2.n2059 17.0005
R1566 vss_1v2.n4016 vss_1v2.n2141 17.0005
R1567 vss_1v2.n4016 vss_1v2.n2058 17.0005
R1568 vss_1v2.n4016 vss_1v2.n2142 17.0005
R1569 vss_1v2.n4016 vss_1v2.n2057 17.0005
R1570 vss_1v2.n4016 vss_1v2.n2143 17.0005
R1571 vss_1v2.n4016 vss_1v2.n2056 17.0005
R1572 vss_1v2.n4016 vss_1v2.n2144 17.0005
R1573 vss_1v2.n3884 vss_1v2.n2279 17.0005
R1574 vss_1v2.n4003 vss_1v2.n2400 17.0005
R1575 vss_1v2.n4016 vss_1v2.n2055 17.0005
R1576 vss_1v2.n4016 vss_1v2.n2146 17.0005
R1577 vss_1v2.n4016 vss_1v2.n2054 17.0005
R1578 vss_1v2.n3890 vss_1v2.n2279 17.0005
R1579 vss_1v2.n4003 vss_1v2.n2324 17.0005
R1580 vss_1v2.n4016 vss_1v2.n2147 17.0005
R1581 vss_1v2.n3894 vss_1v2.n2279 17.0005
R1582 vss_1v2.n4003 vss_1v2.n2403 17.0005
R1583 vss_1v2.n4016 vss_1v2.n2052 17.0005
R1584 vss_1v2.n4016 vss_1v2.n2149 17.0005
R1585 vss_1v2.n4016 vss_1v2.n2051 17.0005
R1586 vss_1v2.n4016 vss_1v2.n2150 17.0005
R1587 vss_1v2.n4003 vss_1v2.n2320 17.0005
R1588 vss_1v2.n3902 vss_1v2.n2279 17.0005
R1589 vss_1v2.n4016 vss_1v2.n2050 17.0005
R1590 vss_1v2.n4016 vss_1v2.n2152 17.0005
R1591 vss_1v2.n3906 vss_1v2.n2279 17.0005
R1592 vss_1v2.n4003 vss_1v2.n2407 17.0005
R1593 vss_1v2.n4016 vss_1v2.n2049 17.0005
R1594 vss_1v2.n4016 vss_1v2.n2154 17.0005
R1595 vss_1v2.n4016 vss_1v2.n2048 17.0005
R1596 vss_1v2.n4016 vss_1v2.n2155 17.0005
R1597 vss_1v2.n4016 vss_1v2.n2047 17.0005
R1598 vss_1v2.n4016 vss_1v2.n2156 17.0005
R1599 vss_1v2.n4016 vss_1v2.n2046 17.0005
R1600 vss_1v2.n4016 vss_1v2.n2157 17.0005
R1601 vss_1v2.n4016 vss_1v2.n2045 17.0005
R1602 vss_1v2.n3918 vss_1v2.n2279 17.0005
R1603 vss_1v2.n4003 vss_1v2.n2313 17.0005
R1604 vss_1v2.n4016 vss_1v2.n2158 17.0005
R1605 vss_1v2.n4016 vss_1v2.n2043 17.0005
R1606 vss_1v2.n4016 vss_1v2.n2159 17.0005
R1607 vss_1v2.n4016 vss_1v2.n2042 17.0005
R1608 vss_1v2.n4016 vss_1v2.n2160 17.0005
R1609 vss_1v2.n4016 vss_1v2.n2041 17.0005
R1610 vss_1v2.n4016 vss_1v2.n2161 17.0005
R1611 vss_1v2.n3928 vss_1v2.n2279 17.0005
R1612 vss_1v2.n4003 vss_1v2.n2413 17.0005
R1613 vss_1v2.n4016 vss_1v2.n2040 17.0005
R1614 vss_1v2.n4016 vss_1v2.n2163 17.0005
R1615 vss_1v2.n4016 vss_1v2.n2039 17.0005
R1616 vss_1v2.n4016 vss_1v2.n2164 17.0005
R1617 vss_1v2.n4016 vss_1v2.n2038 17.0005
R1618 vss_1v2.n4016 vss_1v2.n2165 17.0005
R1619 vss_1v2.n4016 vss_1v2.n2037 17.0005
R1620 vss_1v2.n4016 vss_1v2.n2166 17.0005
R1621 vss_1v2.n4016 vss_1v2.n2036 17.0005
R1622 vss_1v2.n3940 vss_1v2.n2279 17.0005
R1623 vss_1v2.n4003 vss_1v2.n2306 17.0005
R1624 vss_1v2.n4016 vss_1v2.n2167 17.0005
R1625 vss_1v2.n4016 vss_1v2.n2034 17.0005
R1626 vss_1v2.n4016 vss_1v2.n2168 17.0005
R1627 vss_1v2.n4016 vss_1v2.n2033 17.0005
R1628 vss_1v2.n4016 vss_1v2.n2169 17.0005
R1629 vss_1v2.n4016 vss_1v2.n2032 17.0005
R1630 vss_1v2.n4016 vss_1v2.n2170 17.0005
R1631 vss_1v2.n3950 vss_1v2.n2279 17.0005
R1632 vss_1v2.n4003 vss_1v2.n2419 17.0005
R1633 vss_1v2.n4016 vss_1v2.n2031 17.0005
R1634 vss_1v2.n4016 vss_1v2.n2172 17.0005
R1635 vss_1v2.n4016 vss_1v2.n2030 17.0005
R1636 vss_1v2.n4016 vss_1v2.n2173 17.0005
R1637 vss_1v2.n4016 vss_1v2.n2029 17.0005
R1638 vss_1v2.n4016 vss_1v2.n2174 17.0005
R1639 vss_1v2.n4016 vss_1v2.n2028 17.0005
R1640 vss_1v2.n4016 vss_1v2.n2175 17.0005
R1641 vss_1v2.n4016 vss_1v2.n2027 17.0005
R1642 vss_1v2.n3962 vss_1v2.n2279 17.0005
R1643 vss_1v2.n4003 vss_1v2.n2299 17.0005
R1644 vss_1v2.n4016 vss_1v2.n2176 17.0005
R1645 vss_1v2.n4016 vss_1v2.n2025 17.0005
R1646 vss_1v2.n4016 vss_1v2.n2177 17.0005
R1647 vss_1v2.n4016 vss_1v2.n2024 17.0005
R1648 vss_1v2.n4016 vss_1v2.n2178 17.0005
R1649 vss_1v2.n4016 vss_1v2.n2023 17.0005
R1650 vss_1v2.n4016 vss_1v2.n2179 17.0005
R1651 vss_1v2.n4016 vss_1v2.n2022 17.0005
R1652 vss_1v2.n4016 vss_1v2.n2180 17.0005
R1653 vss_1v2.n3974 vss_1v2.n2279 17.0005
R1654 vss_1v2.n4003 vss_1v2.n2426 17.0005
R1655 vss_1v2.n4016 vss_1v2.n2021 17.0005
R1656 vss_1v2.n4016 vss_1v2.n2182 17.0005
R1657 vss_1v2.n4016 vss_1v2.n2020 17.0005
R1658 vss_1v2.n4016 vss_1v2.n2183 17.0005
R1659 vss_1v2.n4016 vss_1v2.n2019 17.0005
R1660 vss_1v2.n4016 vss_1v2.n2184 17.0005
R1661 vss_1v2.n4016 vss_1v2.n2018 17.0005
R1662 vss_1v2.n3984 vss_1v2.n2279 17.0005
R1663 vss_1v2.n4003 vss_1v2.n2293 17.0005
R1664 vss_1v2.n4016 vss_1v2.n2185 17.0005
R1665 vss_1v2.n4016 vss_1v2.n2016 17.0005
R1666 vss_1v2.n4016 vss_1v2.n2186 17.0005
R1667 vss_1v2.n4016 vss_1v2.n2015 17.0005
R1668 vss_1v2.n4016 vss_1v2.n2187 17.0005
R1669 vss_1v2.n4016 vss_1v2.n2014 17.0005
R1670 vss_1v2.n4016 vss_1v2.n2188 17.0005
R1671 vss_1v2.n4016 vss_1v2.n2013 17.0005
R1672 vss_1v2.n4016 vss_1v2.n2189 17.0005
R1673 vss_1v2.n3996 vss_1v2.n2279 17.0005
R1674 vss_1v2.n4003 vss_1v2.n3999 17.0005
R1675 vss_1v2.n4016 vss_1v2.n2012 17.0005
R1676 vss_1v2.n4016 vss_1v2.n2191 17.0005
R1677 vss_1v2.n4016 vss_1v2.n2011 17.0005
R1678 vss_1v2.n4016 vss_1v2.n2192 17.0005
R1679 vss_1v2.n4016 vss_1v2.n2010 17.0005
R1680 vss_1v2.n4016 vss_1v2.n2193 17.0005
R1681 vss_1v2.n4016 vss_1v2.n2009 17.0005
R1682 vss_1v2.n4016 vss_1v2.n2194 17.0005
R1683 vss_1v2.n4016 vss_1v2.n2008 17.0005
R1684 vss_1v2.n2286 vss_1v2.n2279 17.0005
R1685 vss_1v2.n4004 vss_1v2.n4003 17.0005
R1686 vss_1v2.n4016 vss_1v2.n2195 17.0005
R1687 vss_1v2.n4016 vss_1v2.n2006 17.0005
R1688 vss_1v2.n4016 vss_1v2.n2196 17.0005
R1689 vss_1v2.n4016 vss_1v2.n2005 17.0005
R1690 vss_1v2.n4016 vss_1v2.n2197 17.0005
R1691 vss_1v2.n4016 vss_1v2.n2004 17.0005
R1692 vss_1v2.n4016 vss_1v2.n2198 17.0005
R1693 vss_1v2.n4014 vss_1v2.n2279 17.0005
R1694 vss_1v2.n4003 vss_1v2.n2199 17.0005
R1695 vss_1v2.n4016 vss_1v2.n2003 17.0005
R1696 vss_1v2.n35 vss_1v2.n16 0.712027
R1697 vss_1v2.n366 vss_1v2.n2 0.625495
R1698 vss_1v2.n72 vss_1v2.n218 8.50041
R1699 vss_1v2.n3201 vss_1v2.n18 17.0005
R1700 vss_1v2.n3198 vss_1v2.n18 17.0005
R1701 vss_1v2.n3194 vss_1v2.n18 17.0005
R1702 vss_1v2.n16 vss_1v2.n3185 17.0005
R1703 vss_1v2.n3174 vss_1v2.n16 17.0005
R1704 vss_1v2.n16 vss_1v2.n210 17.0005
R1705 vss_1v2.n3073 vss_1v2.n16 17.0005
R1706 vss_1v2.n4090 vss_1v2.n4088 17.0005
R1707 vss_1v2.n4079 vss_1v2.n265 17.0005
R1708 vss_1v2.n80 vss_1v2.n1994 17.0005
R1709 vss_1v2.t332 vss_1v2.n1997 17.0005
R1710 vss_1v2.n1998 vss_1v2.t332 17.0005
R1711 vss_1v2.n74 vss_1v2.n2446 17.0005
R1712 vss_1v2.n74 vss_1v2.n212 17.0005
R1713 vss_1v2.n3843 vss_1v2.n3842 17.0005
R1714 vss_1v2.n3842 vss_1v2.n2442 17.0005
R1715 vss_1v2.n75 vss_1v2.n216 8.5015
R1716 vss_1v2.n74 vss_1v2.n215 17.0005
R1717 vss_1v2.n74 vss_1v2.n214 17.0005
R1718 vss_1v2.n74 vss_1v2.n213 17.0005
R1719 vss_1v2.n2445 vss_1v2.t39 17.0005
R1720 vss_1v2.t39 vss_1v2.n2444 17.0005
R1721 vss_1v2.n4100 vss_1v2.n72 8.50066
R1722 vss_1v2.t42 vss_1v2.n4083 17.0005
R1723 vss_1v2.n4084 vss_1v2.t42 17.0005
R1724 vss_1v2.n4040 vss_1v2.t110 17.0005
R1725 vss_1v2.t110 vss_1v2.n4039 17.0005
R1726 vss_1v2.t125 vss_1v2.n3012 17.0005
R1727 vss_1v2.n3015 vss_1v2.t125 17.0005
R1728 vss_1v2.t145 vss_1v2.n3203 17.0005
R1729 vss_1v2.t145 vss_1v2.n3186 17.0005
R1730 vss_1v2.n3205 vss_1v2.t134 17.0005
R1731 vss_1v2.n3071 vss_1v2.t116 17.0005
R1732 vss_1v2.t116 vss_1v2.n3032 17.0005
R1733 vss_1v2.t87 vss_1v2.n4051 17.0005
R1734 vss_1v2.t87 vss_1v2.n4067 17.0005
R1735 vss_1v2.t74 vss_1v2.n4047 17.0005
R1736 vss_1v2.n4070 vss_1v2.t74 17.0005
R1737 vss_1v2.n4092 vss_1v2.t313 17.0005
R1738 vss_1v2.t313 vss_1v2.n4091 17.0005
R1739 vss_1v2.n3075 vss_1v2.t117 15.6467
R1740 vss_1v2.n3196 vss_1v2.t144 15.4929
R1741 vss_1v2.n4044 vss_1v2.n1967 15.439
R1742 vss_1v2.n3195 vss_1v2.t144 15.4141
R1743 vss_1v2.n3206 vss_1v2.t133 15.259
R1744 vss_1v2.t34 vss_1v2.n4109 15.1793
R1745 vss_1v2.t111 vss_1v2.n4037 15.1728
R1746 vss_1v2.n4038 vss_1v2.t111 15.1728
R1747 vss_1v2.t124 vss_1v2.n3013 15.1728
R1748 vss_1v2.n3016 vss_1v2.t124 15.1728
R1749 vss_1v2.t133 vss_1v2.n3175 15.1728
R1750 vss_1v2.t117 vss_1v2.n3033 15.1728
R1751 vss_1v2.t86 vss_1v2.n4052 15.1728
R1752 vss_1v2.n4066 vss_1v2.t86 15.1728
R1753 vss_1v2.t72 vss_1v2.n4048 15.1728
R1754 vss_1v2.n4071 vss_1v2.t72 15.1728
R1755 vss_1v2.t174 vss_1v2.n3094 15.1618
R1756 vss_1v2.n3029 vss_1v2.t164 15.1618
R1757 vss_1v2.n3403 vss_1v2.t235 15.1618
R1758 vss_1v2.t195 vss_1v2.n3411 15.1618
R1759 vss_1v2.n4036 vss_1v2.t109 15.0005
R1760 vss_1v2.t109 vss_1v2.n4034 15.0005
R1761 vss_1v2.t143 vss_1v2.t154 15.0005
R1762 vss_1v2.t154 vss_1v2.n2844 15.0005
R1763 vss_1v2.n2817 vss_1v2.t96 15.0005
R1764 vss_1v2.t96 vss_1v2.t98 15.0005
R1765 vss_1v2.n3093 vss_1v2.t176 15.0005
R1766 vss_1v2.n3095 vss_1v2.t174 15.0005
R1767 vss_1v2.t176 vss_1v2.n3085 15.0005
R1768 vss_1v2.n3084 vss_1v2.t170 15.0005
R1769 vss_1v2.n3099 vss_1v2.t170 15.0005
R1770 vss_1v2.n3122 vss_1v2.t161 15.0005
R1771 vss_1v2.t164 vss_1v2.n3028 15.0005
R1772 vss_1v2.n3103 vss_1v2.t166 15.0005
R1773 vss_1v2.t166 vss_1v2.n3080 15.0005
R1774 vss_1v2.n3018 vss_1v2.t126 15.0005
R1775 vss_1v2.t126 vss_1v2.n3017 15.0005
R1776 vss_1v2.n2995 vss_1v2.t179 15.0005
R1777 vss_1v2.t179 vss_1v2.t181 15.0005
R1778 vss_1v2.t186 vss_1v2.t185 15.0005
R1779 vss_1v2.n3130 vss_1v2.t186 15.0005
R1780 vss_1v2.n3225 vss_1v2.t198 15.0005
R1781 vss_1v2.t198 vss_1v2.t189 15.0005
R1782 vss_1v2.n3196 vss_1v2.t146 15.0005
R1783 vss_1v2.t146 vss_1v2.n3195 15.0005
R1784 vss_1v2.t191 vss_1v2.t190 15.0005
R1785 vss_1v2.t135 vss_1v2.n3207 15.0005
R1786 vss_1v2.t190 vss_1v2.n3178 15.0005
R1787 vss_1v2.n3172 vss_1v2.t135 15.0005
R1788 vss_1v2.t161 vss_1v2.n3121 15.0005
R1789 vss_1v2.n3076 vss_1v2.t115 15.0005
R1790 vss_1v2.t115 vss_1v2.n3075 15.0005
R1791 vss_1v2.t157 vss_1v2.t156 15.0005
R1792 vss_1v2.t156 vss_1v2.n3049 15.0005
R1793 vss_1v2.t150 vss_1v2.t148 15.0005
R1794 vss_1v2.t148 vss_1v2.n1963 15.0005
R1795 vss_1v2.t78 vss_1v2.t104 15.0005
R1796 vss_1v2.t104 vss_1v2.n4056 15.0005
R1797 vss_1v2.t88 vss_1v2.n4064 15.0005
R1798 vss_1v2.n4065 vss_1v2.t88 15.0005
R1799 vss_1v2.n4073 vss_1v2.t79 15.0005
R1800 vss_1v2.t79 vss_1v2.n4072 15.0005
R1801 vss_1v2.t90 vss_1v2.t91 15.0005
R1802 vss_1v2.n4058 vss_1v2.t90 15.0005
R1803 vss_1v2.t82 vss_1v2.t81 15.0005
R1804 vss_1v2.t81 vss_1v2.n1956 15.0005
R1805 vss_1v2.t67 vss_1v2.t65 15.0005
R1806 vss_1v2.t65 vss_1v2.n4115 15.0005
R1807 vss_1v2.t137 vss_1v2.t138 15.0005
R1808 vss_1v2.n1959 vss_1v2.t137 15.0005
R1809 vss_1v2.t129 vss_1v2.t128 15.0005
R1810 vss_1v2.t128 vss_1v2.n1917 15.0005
R1811 vss_1v2.t120 vss_1v2.t119 15.0005
R1812 vss_1v2.t119 vss_1v2.n1931 15.0005
R1813 vss_1v2.t94 vss_1v2.t93 15.0005
R1814 vss_1v2.t93 vss_1v2.n1938 15.0005
R1815 vss_1v2.t76 vss_1v2.t106 15.0005
R1816 vss_1v2.t106 vss_1v2.n1944 15.0005
R1817 vss_1v2.t205 vss_1v2.n3459 15.0005
R1818 vss_1v2.t207 vss_1v2.t205 15.0005
R1819 vss_1v2.n3450 vss_1v2.t221 15.0005
R1820 vss_1v2.t221 vss_1v2.t211 15.0005
R1821 vss_1v2.n3425 vss_1v2.t237 15.0005
R1822 vss_1v2.t235 vss_1v2.n3424 15.0005
R1823 vss_1v2.t237 vss_1v2.n3401 15.0005
R1824 vss_1v2.t231 vss_1v2.n3404 15.0005
R1825 vss_1v2.n3420 vss_1v2.t231 15.0005
R1826 vss_1v2.n3416 vss_1v2.t227 15.0005
R1827 vss_1v2.t227 vss_1v2.n3415 15.0005
R1828 vss_1v2.t224 vss_1v2.n3412 15.0005
R1829 vss_1v2.n3413 vss_1v2.t195 15.0005
R1830 vss_1v2.n3410 vss_1v2.t224 15.0005
R1831 vss_1v2.n2975 vss_1v2.t254 15.0005
R1832 vss_1v2.t254 vss_1v2.t253 15.0005
R1833 vss_1v2.n3350 vss_1v2.t261 15.0005
R1834 vss_1v2.t261 vss_1v2.t260 15.0005
R1835 vss_1v2.n1982 vss_1v2.t201 15.0005
R1836 vss_1v2.t201 vss_1v2.t204 15.0005
R1837 vss_1v2.n2810 vss_1v2.t216 15.0005
R1838 vss_1v2.t216 vss_1v2.t218 15.0005
R1839 vss_1v2.n2987 vss_1v2.t240 15.0005
R1840 vss_1v2.t240 vss_1v2.t242 15.0005
R1841 vss_1v2.t243 vss_1v2.n3221 15.0005
R1842 vss_1v2.t245 vss_1v2.t243 15.0005
R1843 vss_1v2.n4044 vss_1v2.n50 14.1905
R1844 vss_1v2.n3127 vss_1v2.n3126 14.0355
R1845 vss_1v2.n1909 vss_1v2.n1908 13.8073
R1846 vss_1v2.n1891 vss_1v2.n1890 13.0403
R1847 vss_1v2.n3126 vss_1v2.n3011 12.9005
R1848 vss_1v2.n1909 vss_1v2.t8 11.9056
R1849 vss_1v2.n3070 vss_1v2.n3069 11.028
R1850 vss_1v2.n210 vss_1v2.n3070 10.8905
R1851 vss_1v2.n2862 vss_1v2.n2857 10.7994
R1852 vss_1v2.n4075 vss_1v2.n262 10.7293
R1853 vss_1v2.n4 vss_1v2.n574 10.137
R1854 vss_1v2.n4077 vss_1v2.n4075 9.70695
R1855 vss_1v2.n3167 vss_1v2.n43 9.65448
R1856 vss_1v2.n31 vss_1v2.n50 0.00247122
R1857 vss_1v2.n3004 vss_1v2.n2994 9.54966
R1858 vss_1v2.n4050 vss_1v2.t334 9.39779
R1859 vss_1v2.n1958 vss_1v2.t85 9.39779
R1860 vss_1v2.n3097 vss_1v2.n3096 9.2117
R1861 vss_1v2.n3106 vss_1v2.n3105 9.2117
R1862 vss_1v2.n3423 vss_1v2.n3422 9.2117
R1863 vss_1v2.n3414 vss_1v2.n3408 9.2117
R1864 vss_1v2.n4130 vss_1v2.n574 9.19869
R1865 vss_1v2.n4050 vss_1v2.n1958 9.1877
R1866 vss_1v2.t320 vss_1v2.t132 9.1877
R1867 vss_1v2.n3629 vss_1v2.n3591 9.0005
R1868 vss_1v2.n3629 vss_1v2.n2637 9.0005
R1869 vss_1v2.n3100 vss_1v2.n3083 9.0005
R1870 vss_1v2.n3098 vss_1v2.n3097 9.0005
R1871 vss_1v2.n3105 vss_1v2.n3104 9.0005
R1872 vss_1v2.n3082 vss_1v2.n3081 9.0005
R1873 vss_1v2.n3422 vss_1v2.n3421 9.0005
R1874 vss_1v2.n3406 vss_1v2.n3405 9.0005
R1875 vss_1v2.n3418 vss_1v2.n3417 9.0005
R1876 vss_1v2.n3409 vss_1v2.n3408 9.0005
R1877 vss_1v2.n3011 vss_1v2.n3010 8.88539
R1878 vss_1v2.n3209 vss_1v2.n3208 8.88539
R1879 vss_1v2.n3113 vss_1v2.n1295 8.88539
R1880 vss_1v2.n3058 vss_1v2.n3034 8.87297
R1881 vss_1v2.n83 vss_1v2.n2 4.23254
R1882 vss_1v2.n3011 vss_1v2.n2993 8.73146
R1883 vss_1v2.n3113 vss_1v2.n3079 8.73146
R1884 vss_1v2.n3011 vss_1v2.n209 0.206488
R1885 vss_1v2.n3208 vss_1v2.n3171 8.72693
R1886 vss_1v2.n49 vss_1v2.n16 4.19756
R1887 vss_1v2.n3114 vss_1v2.n3113 8.70672
R1888 vss_1v2.n76 vss_1v2.n16 2.95894
R1889 vss_1v2.n3123 vss_1v2.n3027 8.56065
R1890 vss_1v2.n3170 vss_1v2.n3169 8.5282
R1891 vss_1v2.n1303 vss_1v2.n219 8.52771
R1892 vss_1v2.n3007 vss_1v2.n3006 8.50175
R1893 vss_1v2.n3209 vss_1v2.n2983 8.50175
R1894 vss_1v2.n3024 vss_1v2.n2828 8.50175
R1895 vss_1v2.n3037 vss_1v2.n1295 8.50175
R1896 vss_1v2.n3117 vss_1v2.n3116 8.50175
R1897 vss_1v2.n3046 vss_1v2.n3045 8.50175
R1898 vss_1v2.n4133 vss_1v2.n1250 8.50175
R1899 vss_1v2.n1287 vss_1v2.n1276 8.50175
R1900 vss_1v2.n3054 vss_1v2.n3053 8.50175
R1901 vss_1v2.n42 vss_1v2.n18 0.676244
R1902 vss_1v2.n4132 vss_1v2.n1008 8.501
R1903 vss_1v2.n4133 vss_1v2.n1276 8.501
R1904 vss_1v2.n1275 vss_1v2.n1010 8.501
R1905 vss_1v2.n3318 vss_1v2.n951 8.501
R1906 vss_1v2.n3315 vss_1v2.n950 8.501
R1907 vss_1v2.n3319 vss_1v2.n3318 8.501
R1908 vss_1v2.n3321 vss_1v2.n950 8.501
R1909 vss_1v2.n3318 vss_1v2.n1272 8.501
R1910 vss_1v2.n4132 vss_1v2.n1285 8.501
R1911 vss_1v2.n3168 vss_1v2.n1010 8.501
R1912 vss_1v2.n4132 vss_1v2.n1290 8.501
R1913 vss_1v2.n1251 vss_1v2.n1010 8.501
R1914 vss_1v2.n1289 vss_1v2.n1250 8.501
R1915 vss_1v2.n1224 vss_1v2.n1220 8.501
R1916 vss_1v2.n3558 vss_1v2.n2832 8.501
R1917 vss_1v2.n3230 vss_1v2.n1220 8.501
R1918 vss_1v2.n3558 vss_1v2.n2833 8.501
R1919 vss_1v2.n3214 vss_1v2.n1220 8.501
R1920 vss_1v2.n3166 vss_1v2.n1220 8.501
R1921 vss_1v2.n3558 vss_1v2.n2830 8.501
R1922 vss_1v2.n3558 vss_1v2.n2834 8.501
R1923 vss_1v2.n3135 vss_1v2.n1220 8.501
R1924 vss_1v2.n3558 vss_1v2.n2829 8.501
R1925 vss_1v2.n3143 vss_1v2.n1220 8.501
R1926 vss_1v2.n4132 vss_1v2.n1293 8.501
R1927 vss_1v2.n3008 vss_1v2.n3007 8.501
R1928 vss_1v2.n3005 vss_1v2.n1010 8.501
R1929 vss_1v2.n4132 vss_1v2.n1292 8.501
R1930 vss_1v2.n3001 vss_1v2.n1010 8.501
R1931 vss_1v2.n3000 vss_1v2.n2983 8.501
R1932 vss_1v2.n3078 vss_1v2.n1010 8.501
R1933 vss_1v2.n4132 vss_1v2.n1294 8.501
R1934 vss_1v2.n3119 vss_1v2.n1010 8.501
R1935 vss_1v2.n4132 vss_1v2.n1281 8.501
R1936 vss_1v2.n3118 vss_1v2.n3117 8.501
R1937 vss_1v2.n4132 vss_1v2.n1282 8.501
R1938 vss_1v2.n3115 vss_1v2.n1010 8.501
R1939 vss_1v2.n4132 vss_1v2.n1283 8.501
R1940 vss_1v2.n3026 vss_1v2.n1010 8.501
R1941 vss_1v2.n2992 vss_1v2.n1010 8.501
R1942 vss_1v2.n3025 vss_1v2.n3024 8.501
R1943 vss_1v2.n2895 vss_1v2.n1220 8.501
R1944 vss_1v2.n3558 vss_1v2.n2827 8.501
R1945 vss_1v2.n2891 vss_1v2.n1220 8.501
R1946 vss_1v2.n3558 vss_1v2.n2836 8.501
R1947 vss_1v2.n3060 vss_1v2.n1220 8.501
R1948 vss_1v2.n3558 vss_1v2.n2837 8.501
R1949 vss_1v2.n2687 vss_1v2.n1220 8.501
R1950 vss_1v2.n3558 vss_1v2.n2685 8.501
R1951 vss_1v2.n3578 vss_1v2.n1220 8.501
R1952 vss_1v2.n3559 vss_1v2.n3558 8.501
R1953 vss_1v2.n2816 vss_1v2.n1220 8.501
R1954 vss_1v2.n4132 vss_1v2.n1277 8.501
R1955 vss_1v2.n3045 vss_1v2.n3044 8.501
R1956 vss_1v2.n3043 vss_1v2.n1010 8.501
R1957 vss_1v2.n3047 vss_1v2.n1010 8.501
R1958 vss_1v2.n4132 vss_1v2.n1278 8.501
R1959 vss_1v2.n3054 vss_1v2.n3051 8.501
R1960 vss_1v2.n3052 vss_1v2.n1010 8.501
R1961 vss_1v2.n4132 vss_1v2.n1279 8.501
R1962 vss_1v2.n4132 vss_1v2.n1280 8.501
R1963 vss_1v2.n3038 vss_1v2.n1010 8.501
R1964 vss_1v2.n3035 vss_1v2.n1010 8.501
R1965 vss_1v2.n3037 vss_1v2.n3036 8.501
R1966 vss_1v2.n2 vss_1v2.n5 5.66778
R1967 vss_1v2.n3558 vss_1v2.n3557 8.501
R1968 vss_1v2.n220 vss_1v2.n1220 8.501
R1969 vss_1v2.n396 vss_1v2.n1985 8.501
R1970 vss_1v2.n396 vss_1v2.n1986 8.501
R1971 vss_1v2.n396 vss_1v2.n1987 8.501
R1972 vss_1v2.n3507 vss_1v2.n2863 8.501
R1973 vss_1v2.n3512 vss_1v2.n2863 8.501
R1974 vss_1v2.n2864 vss_1v2.n2863 8.501
R1975 vss_1v2.n3521 vss_1v2.n2863 8.501
R1976 vss_1v2.n3526 vss_1v2.n2863 8.501
R1977 vss_1v2.n2863 vss_1v2.n2851 8.501
R1978 vss_1v2.n2863 vss_1v2.n936 8.501
R1979 vss_1v2.n2866 vss_1v2.n935 8.501
R1980 vss_1v2.n3514 vss_1v2.n935 8.501
R1981 vss_1v2.n3519 vss_1v2.n935 8.501
R1982 vss_1v2.n3523 vss_1v2.n935 8.501
R1983 vss_1v2.n3529 vss_1v2.n935 8.501
R1984 vss_1v2.n2860 vss_1v2.n935 8.501
R1985 vss_1v2.n3550 vss_1v2.n935 8.501
R1986 vss_1v2.n3585 vss_1v2.n2674 8.501
R1987 vss_1v2.n3569 vss_1v2.n2664 8.501
R1988 vss_1v2.n3569 vss_1v2.n308 8.501
R1989 vss_1v2.n3585 vss_1v2.n309 8.501
R1990 vss_1v2.n3569 vss_1v2.n307 8.501
R1991 vss_1v2.n3585 vss_1v2.n305 8.501
R1992 vss_1v2.n3569 vss_1v2.n303 8.501
R1993 vss_1v2.n3585 vss_1v2.n2672 8.501
R1994 vss_1v2.n3585 vss_1v2.n350 8.501
R1995 vss_1v2.n3569 vss_1v2.n2696 8.501
R1996 vss_1v2.n353 vss_1v2.n2899 8.501
R1997 vss_1v2.n3569 vss_1v2.n2809 8.501
R1998 vss_1v2.n3585 vss_1v2.n2669 8.501
R1999 vss_1v2.n3569 vss_1v2.n2694 8.501
R2000 vss_1v2.n3569 vss_1v2.n2807 8.501
R2001 vss_1v2.n3585 vss_1v2.n2667 8.501
R2002 vss_1v2.n3585 vss_1v2.n2668 8.501
R2003 vss_1v2.n3570 vss_1v2.n3569 8.501
R2004 vss_1v2.n4029 vss_1v2.n408 8.501
R2005 vss_1v2.n2522 vss_1v2.n2512 8.501
R2006 vss_1v2.n3832 vss_1v2.n2522 8.501
R2007 vss_1v2.n2522 vss_1v2.n2521 8.501
R2008 vss_1v2.n2522 vss_1v2.n2520 8.501
R2009 vss_1v2.n2522 vss_1v2.n2519 8.501
R2010 vss_1v2.n2522 vss_1v2.n2513 8.501
R2011 vss_1v2.n2522 vss_1v2.n2447 8.501
R2012 vss_1v2.n2522 vss_1v2.n2514 8.501
R2013 vss_1v2.n2522 vss_1v2.n2515 8.501
R2014 vss_1v2.n2522 vss_1v2.n2516 8.501
R2015 vss_1v2.n2522 vss_1v2.n2518 8.501
R2016 vss_1v2.n3836 vss_1v2.n3835 8.501
R2017 vss_1v2.n3835 vss_1v2.n3818 8.501
R2018 vss_1v2.n3835 vss_1v2.n3828 8.501
R2019 vss_1v2.n3835 vss_1v2.n3827 8.501
R2020 vss_1v2.n3835 vss_1v2.n3826 8.501
R2021 vss_1v2.n3835 vss_1v2.n3819 8.501
R2022 vss_1v2.n3835 vss_1v2.n3825 8.501
R2023 vss_1v2.n3835 vss_1v2.n2448 8.501
R2024 vss_1v2.n3835 vss_1v2.n3824 8.501
R2025 vss_1v2.n3835 vss_1v2.n3820 8.501
R2026 vss_1v2.n3835 vss_1v2.n3823 8.501
R2027 vss_1v2.n3835 vss_1v2.n3821 8.501
R2028 vss_1v2.n4003 vss_1v2.n2356 8.501
R2029 vss_1v2.n4016 vss_1v2.n2095 8.501
R2030 vss_1v2.n2354 vss_1v2.n2279 8.501
R2031 vss_1v2.n4003 vss_1v2.n2358 8.501
R2032 vss_1v2.n2279 vss_1v2.n2239 8.501
R2033 vss_1v2.n4003 vss_1v2.n2359 8.501
R2034 vss_1v2.n2279 vss_1v2.n2240 8.501
R2035 vss_1v2.n4003 vss_1v2.n2360 8.501
R2036 vss_1v2.n2279 vss_1v2.n2241 8.501
R2037 vss_1v2.n4003 vss_1v2.n2361 8.501
R2038 vss_1v2.n4016 vss_1v2.n2100 8.501
R2039 vss_1v2.n2362 vss_1v2.n2279 8.501
R2040 vss_1v2.n4003 vss_1v2.n2353 8.501
R2041 vss_1v2.n2279 vss_1v2.n2238 8.501
R2042 vss_1v2.n4003 vss_1v2.n2352 8.501
R2043 vss_1v2.n2279 vss_1v2.n2237 8.501
R2044 vss_1v2.n4003 vss_1v2.n2351 8.501
R2045 vss_1v2.n2279 vss_1v2.n2236 8.501
R2046 vss_1v2.n4003 vss_1v2.n2350 8.501
R2047 vss_1v2.n2279 vss_1v2.n2235 8.501
R2048 vss_1v2.n4003 vss_1v2.n2349 8.501
R2049 vss_1v2.n4016 vss_1v2.n2092 8.501
R2050 vss_1v2.n2348 vss_1v2.n2279 8.501
R2051 vss_1v2.n4003 vss_1v2.n2364 8.501
R2052 vss_1v2.n2279 vss_1v2.n2242 8.501
R2053 vss_1v2.n4003 vss_1v2.n2365 8.501
R2054 vss_1v2.n2279 vss_1v2.n2243 8.501
R2055 vss_1v2.n4003 vss_1v2.n2366 8.501
R2056 vss_1v2.n2279 vss_1v2.n2244 8.501
R2057 vss_1v2.n4003 vss_1v2.n2367 8.501
R2058 vss_1v2.n4016 vss_1v2.n2105 8.501
R2059 vss_1v2.n2368 vss_1v2.n2279 8.501
R2060 vss_1v2.n4003 vss_1v2.n2347 8.501
R2061 vss_1v2.n2279 vss_1v2.n2234 8.501
R2062 vss_1v2.n4003 vss_1v2.n2346 8.501
R2063 vss_1v2.n2279 vss_1v2.n2233 8.501
R2064 vss_1v2.n4003 vss_1v2.n2345 8.501
R2065 vss_1v2.n2279 vss_1v2.n2232 8.501
R2066 vss_1v2.n4003 vss_1v2.n2344 8.501
R2067 vss_1v2.n2279 vss_1v2.n2231 8.501
R2068 vss_1v2.n4003 vss_1v2.n2343 8.501
R2069 vss_1v2.n4016 vss_1v2.n2083 8.501
R2070 vss_1v2.n2341 vss_1v2.n2279 8.501
R2071 vss_1v2.n4003 vss_1v2.n2370 8.501
R2072 vss_1v2.n2279 vss_1v2.n2245 8.501
R2073 vss_1v2.n4003 vss_1v2.n2371 8.501
R2074 vss_1v2.n2279 vss_1v2.n2246 8.501
R2075 vss_1v2.n4003 vss_1v2.n2372 8.501
R2076 vss_1v2.n2279 vss_1v2.n2247 8.501
R2077 vss_1v2.n4003 vss_1v2.n2373 8.501
R2078 vss_1v2.n4016 vss_1v2.n2112 8.501
R2079 vss_1v2.n2374 vss_1v2.n2279 8.501
R2080 vss_1v2.n4003 vss_1v2.n2340 8.501
R2081 vss_1v2.n2279 vss_1v2.n2230 8.501
R2082 vss_1v2.n4003 vss_1v2.n2339 8.501
R2083 vss_1v2.n2279 vss_1v2.n2229 8.501
R2084 vss_1v2.n4003 vss_1v2.n2338 8.501
R2085 vss_1v2.n4016 vss_1v2.n2079 8.501
R2086 vss_1v2.n2337 vss_1v2.n2279 8.501
R2087 vss_1v2.n4003 vss_1v2.n2376 8.501
R2088 vss_1v2.n2279 vss_1v2.n2248 8.501
R2089 vss_1v2.n4003 vss_1v2.n2377 8.501
R2090 vss_1v2.n2279 vss_1v2.n2249 8.501
R2091 vss_1v2.n4003 vss_1v2.n2378 8.501
R2092 vss_1v2.n2279 vss_1v2.n2250 8.501
R2093 vss_1v2.n4003 vss_1v2.n2379 8.501
R2094 vss_1v2.n2279 vss_1v2.n2251 8.501
R2095 vss_1v2.n4003 vss_1v2.n2380 8.501
R2096 vss_1v2.n4016 vss_1v2.n2123 8.501
R2097 vss_1v2.n2381 vss_1v2.n2279 8.501
R2098 vss_1v2.n4003 vss_1v2.n2336 8.501
R2099 vss_1v2.n2279 vss_1v2.n2228 8.501
R2100 vss_1v2.n4003 vss_1v2.n2335 8.501
R2101 vss_1v2.n2279 vss_1v2.n2227 8.501
R2102 vss_1v2.n4003 vss_1v2.n2334 8.501
R2103 vss_1v2.n2279 vss_1v2.n2002 8.501
R2104 vss_1v2.n4003 vss_1v2.n2001 8.501
R2105 vss_1v2.n3366 vss_1v2.n2524 8.501
R2106 vss_1v2.n3367 vss_1v2.n3366 8.501
R2107 vss_1v2.n3356 vss_1v2.n2523 8.501
R2108 vss_1v2.n3366 vss_1v2.n3354 8.501
R2109 vss_1v2.n3369 vss_1v2.n2523 8.501
R2110 vss_1v2.n374 vss_1v2.n3352 8.501
R2111 vss_1v2.n3482 vss_1v2.n2937 8.501
R2112 vss_1v2.n467 vss_1v2.n2978 8.501
R2113 vss_1v2.n2909 vss_1v2.n2906 8.501
R2114 vss_1v2.n2873 vss_1v2.n2870 8.501
R2115 vss_1v2.n3455 vss_1v2.n2951 8.501
R2116 vss_1v2.n3482 vss_1v2.n2932 8.501
R2117 vss_1v2.n3455 vss_1v2.n2950 8.501
R2118 vss_1v2.n3482 vss_1v2.n1971 8.501
R2119 vss_1v2.n2119 vss_1v2.n1972 8.501
R2120 vss_1v2.n3455 vss_1v2.n2943 8.501
R2121 vss_1v2.n3482 vss_1v2.n3481 8.501
R2122 vss_1v2.n4125 vss_1v2.n1854 8.501
R2123 vss_1v2.n4125 vss_1v2.n4124 8.501
R2124 vss_1v2.n4126 vss_1v2.n4125 8.501
R2125 vss_1v2.n4125 vss_1v2.n718 8.501
R2126 vss_1v2.n4016 vss_1v2.n2127 8.501
R2127 vss_1v2.n2332 vss_1v2.n2279 8.501
R2128 vss_1v2.n4003 vss_1v2.n2383 8.501
R2129 vss_1v2.n4016 vss_1v2.n2071 8.501
R2130 vss_1v2.n2384 vss_1v2.n2279 8.501
R2131 vss_1v2.n4003 vss_1v2.n2331 8.501
R2132 vss_1v2.n2279 vss_1v2.n2252 8.501
R2133 vss_1v2.n4003 vss_1v2.n2330 8.501
R2134 vss_1v2.n2279 vss_1v2.n2226 8.501
R2135 vss_1v2.n4003 vss_1v2.n2329 8.501
R2136 vss_1v2.n4016 vss_1v2.n2131 8.501
R2137 vss_1v2.n2327 vss_1v2.n2279 8.501
R2138 vss_1v2.n4003 vss_1v2.n2386 8.501
R2139 vss_1v2.n2279 vss_1v2.n2225 8.501
R2140 vss_1v2.n4003 vss_1v2.n2387 8.501
R2141 vss_1v2.n2279 vss_1v2.n2253 8.501
R2142 vss_1v2.n4003 vss_1v2.n2388 8.501
R2143 vss_1v2.n2279 vss_1v2.n2224 8.501
R2144 vss_1v2.n4003 vss_1v2.n2389 8.501
R2145 vss_1v2.n2279 vss_1v2.n2254 8.501
R2146 vss_1v2.n4003 vss_1v2.n2390 8.501
R2147 vss_1v2.n2279 vss_1v2.n2223 8.501
R2148 vss_1v2.n4003 vss_1v2.n2391 8.501
R2149 vss_1v2.n2279 vss_1v2.n2255 8.501
R2150 vss_1v2.n4003 vss_1v2.n2392 8.501
R2151 vss_1v2.n2279 vss_1v2.n2222 8.501
R2152 vss_1v2.n4003 vss_1v2.n2393 8.501
R2153 vss_1v2.n2279 vss_1v2.n2256 8.501
R2154 vss_1v2.n4003 vss_1v2.n2394 8.501
R2155 vss_1v2.n2279 vss_1v2.n2257 8.501
R2156 vss_1v2.n4003 vss_1v2.n2395 8.501
R2157 vss_1v2.n2279 vss_1v2.n2258 8.501
R2158 vss_1v2.n4003 vss_1v2.n2396 8.501
R2159 vss_1v2.n2279 vss_1v2.n2259 8.501
R2160 vss_1v2.n4003 vss_1v2.n2397 8.501
R2161 vss_1v2.n2279 vss_1v2.n2260 8.501
R2162 vss_1v2.n4003 vss_1v2.n2398 8.501
R2163 vss_1v2.n4016 vss_1v2.n2145 8.501
R2164 vss_1v2.n2399 vss_1v2.n2279 8.501
R2165 vss_1v2.n4003 vss_1v2.n2326 8.501
R2166 vss_1v2.n2279 vss_1v2.n2221 8.501
R2167 vss_1v2.n4003 vss_1v2.n2325 8.501
R2168 vss_1v2.n4016 vss_1v2.n2053 8.501
R2169 vss_1v2.n2323 vss_1v2.n2279 8.501
R2170 vss_1v2.n4003 vss_1v2.n2401 8.501
R2171 vss_1v2.n4016 vss_1v2.n2148 8.501
R2172 vss_1v2.n2402 vss_1v2.n2279 8.501
R2173 vss_1v2.n4003 vss_1v2.n2322 8.501
R2174 vss_1v2.n2279 vss_1v2.n2220 8.501
R2175 vss_1v2.n4003 vss_1v2.n2321 8.501
R2176 vss_1v2.n2319 vss_1v2.n2279 8.501
R2177 vss_1v2.n4016 vss_1v2.n2151 8.501
R2178 vss_1v2.n4003 vss_1v2.n2404 8.501
R2179 vss_1v2.n2279 vss_1v2.n2261 8.501
R2180 vss_1v2.n4003 vss_1v2.n2405 8.501
R2181 vss_1v2.n4016 vss_1v2.n2153 8.501
R2182 vss_1v2.n2406 vss_1v2.n2279 8.501
R2183 vss_1v2.n4003 vss_1v2.n2318 8.501
R2184 vss_1v2.n2279 vss_1v2.n2219 8.501
R2185 vss_1v2.n4003 vss_1v2.n2317 8.501
R2186 vss_1v2.n2279 vss_1v2.n2218 8.501
R2187 vss_1v2.n4003 vss_1v2.n2316 8.501
R2188 vss_1v2.n2279 vss_1v2.n2217 8.501
R2189 vss_1v2.n4003 vss_1v2.n2315 8.501
R2190 vss_1v2.n2279 vss_1v2.n2216 8.501
R2191 vss_1v2.n4003 vss_1v2.n2314 8.501
R2192 vss_1v2.n4016 vss_1v2.n2044 8.501
R2193 vss_1v2.n2312 vss_1v2.n2279 8.501
R2194 vss_1v2.n4003 vss_1v2.n2408 8.501
R2195 vss_1v2.n2279 vss_1v2.n2262 8.501
R2196 vss_1v2.n4003 vss_1v2.n2409 8.501
R2197 vss_1v2.n2279 vss_1v2.n2263 8.501
R2198 vss_1v2.n4003 vss_1v2.n2410 8.501
R2199 vss_1v2.n2279 vss_1v2.n2264 8.501
R2200 vss_1v2.n4003 vss_1v2.n2411 8.501
R2201 vss_1v2.n4016 vss_1v2.n2162 8.501
R2202 vss_1v2.n2412 vss_1v2.n2279 8.501
R2203 vss_1v2.n4003 vss_1v2.n2311 8.501
R2204 vss_1v2.n2279 vss_1v2.n2215 8.501
R2205 vss_1v2.n4003 vss_1v2.n2310 8.501
R2206 vss_1v2.n2279 vss_1v2.n2214 8.501
R2207 vss_1v2.n4003 vss_1v2.n2309 8.501
R2208 vss_1v2.n2279 vss_1v2.n2213 8.501
R2209 vss_1v2.n4003 vss_1v2.n2308 8.501
R2210 vss_1v2.n2279 vss_1v2.n2212 8.501
R2211 vss_1v2.n4003 vss_1v2.n2307 8.501
R2212 vss_1v2.n4016 vss_1v2.n2035 8.501
R2213 vss_1v2.n2305 vss_1v2.n2279 8.501
R2214 vss_1v2.n4003 vss_1v2.n2414 8.501
R2215 vss_1v2.n2279 vss_1v2.n2265 8.501
R2216 vss_1v2.n4003 vss_1v2.n2415 8.501
R2217 vss_1v2.n2279 vss_1v2.n2266 8.501
R2218 vss_1v2.n4003 vss_1v2.n2416 8.501
R2219 vss_1v2.n2279 vss_1v2.n2267 8.501
R2220 vss_1v2.n4003 vss_1v2.n2417 8.501
R2221 vss_1v2.n4016 vss_1v2.n2171 8.501
R2222 vss_1v2.n2418 vss_1v2.n2279 8.501
R2223 vss_1v2.n4003 vss_1v2.n2304 8.501
R2224 vss_1v2.n2279 vss_1v2.n2211 8.501
R2225 vss_1v2.n4003 vss_1v2.n2303 8.501
R2226 vss_1v2.n2279 vss_1v2.n2210 8.501
R2227 vss_1v2.n4003 vss_1v2.n2302 8.501
R2228 vss_1v2.n2279 vss_1v2.n2209 8.501
R2229 vss_1v2.n4003 vss_1v2.n2301 8.501
R2230 vss_1v2.n2279 vss_1v2.n2208 8.501
R2231 vss_1v2.n4003 vss_1v2.n2300 8.501
R2232 vss_1v2.n4016 vss_1v2.n2026 8.501
R2233 vss_1v2.n2298 vss_1v2.n2279 8.501
R2234 vss_1v2.n4003 vss_1v2.n2420 8.501
R2235 vss_1v2.n2279 vss_1v2.n2268 8.501
R2236 vss_1v2.n4003 vss_1v2.n2421 8.501
R2237 vss_1v2.n2279 vss_1v2.n2269 8.501
R2238 vss_1v2.n4003 vss_1v2.n2422 8.501
R2239 vss_1v2.n2279 vss_1v2.n2270 8.501
R2240 vss_1v2.n4003 vss_1v2.n2423 8.501
R2241 vss_1v2.n2279 vss_1v2.n2271 8.501
R2242 vss_1v2.n4003 vss_1v2.n2424 8.501
R2243 vss_1v2.n4016 vss_1v2.n2181 8.501
R2244 vss_1v2.n2425 vss_1v2.n2279 8.501
R2245 vss_1v2.n4003 vss_1v2.n2297 8.501
R2246 vss_1v2.n2279 vss_1v2.n2207 8.501
R2247 vss_1v2.n4003 vss_1v2.n2296 8.501
R2248 vss_1v2.n2279 vss_1v2.n2206 8.501
R2249 vss_1v2.n4003 vss_1v2.n2295 8.501
R2250 vss_1v2.n2279 vss_1v2.n2205 8.501
R2251 vss_1v2.n4003 vss_1v2.n2294 8.501
R2252 vss_1v2.n4016 vss_1v2.n2017 8.501
R2253 vss_1v2.n2292 vss_1v2.n2279 8.501
R2254 vss_1v2.n4003 vss_1v2.n2427 8.501
R2255 vss_1v2.n2279 vss_1v2.n2272 8.501
R2256 vss_1v2.n4003 vss_1v2.n2428 8.501
R2257 vss_1v2.n2279 vss_1v2.n2273 8.501
R2258 vss_1v2.n4003 vss_1v2.n2429 8.501
R2259 vss_1v2.n2279 vss_1v2.n2274 8.501
R2260 vss_1v2.n4003 vss_1v2.n2430 8.501
R2261 vss_1v2.n2279 vss_1v2.n2275 8.501
R2262 vss_1v2.n4003 vss_1v2.n2431 8.501
R2263 vss_1v2.n4016 vss_1v2.n2190 8.501
R2264 vss_1v2.n2432 vss_1v2.n2279 8.501
R2265 vss_1v2.n4003 vss_1v2.n2291 8.501
R2266 vss_1v2.n2279 vss_1v2.n2204 8.501
R2267 vss_1v2.n4003 vss_1v2.n2290 8.501
R2268 vss_1v2.n2279 vss_1v2.n2203 8.501
R2269 vss_1v2.n4003 vss_1v2.n2289 8.501
R2270 vss_1v2.n2279 vss_1v2.n2202 8.501
R2271 vss_1v2.n4003 vss_1v2.n2288 8.501
R2272 vss_1v2.n2279 vss_1v2.n2201 8.501
R2273 vss_1v2.n4003 vss_1v2.n2287 8.501
R2274 vss_1v2.n4016 vss_1v2.n2007 8.501
R2275 vss_1v2.n2284 vss_1v2.n2279 8.501
R2276 vss_1v2.n4003 vss_1v2.n4000 8.501
R2277 vss_1v2.n2279 vss_1v2.n2276 8.501
R2278 vss_1v2.n4003 vss_1v2.n4001 8.501
R2279 vss_1v2.n2279 vss_1v2.n2277 8.501
R2280 vss_1v2.n4003 vss_1v2.n4002 8.501
R2281 vss_1v2.n2279 vss_1v2.n2278 8.501
R2282 vss_1v2.n4003 vss_1v2.n2280 8.501
R2283 vss_1v2.n4016 vss_1v2.n4015 8.501
R2284 vss_1v2.n2279 vss_1v2.n2200 8.501
R2285 vss_1v2.n4003 vss_1v2.n1898 8.501
R2286 vss_1v2.n4117 vss_1v2.n16 0.555424
R2287 vss_1v2.n2 vss_1v2.n44 0.497276
R2288 vss_1v2.n2 vss_1v2.n3057 8.501
R2289 vss_1v2.n4117 vss_1v2.n2 1.02773
R2290 vss_1v2.n18 vss_1v2.n44 0.849441
R2291 vss_1v2.n4131 vss_1v2.n2 0.35572
R2292 vss_1v2.n3113 vss_1v2.n76 0.0016303
R2293 vss_1v2.n4131 vss_1v2.n22 0.0893282
R2294 vss_1v2.n74 vss_1v2.n217 2.12531
R2295 vss_1v2.n72 vss_1v2.n4096 8.501
R2296 vss_1v2.n18 vss_1v2.n1839 8.5005
R2297 vss_1v2.n18 vss_1v2.n1338 8.5005
R2298 vss_1v2.n18 vss_1v2.n1838 8.5005
R2299 vss_1v2.n18 vss_1v2.n1339 8.5005
R2300 vss_1v2.n18 vss_1v2.n1453 8.5005
R2301 vss_1v2.n18 vss_1v2.n1340 8.5005
R2302 vss_1v2.n18 vss_1v2.n1452 8.5005
R2303 vss_1v2.n18 vss_1v2.n1341 8.5005
R2304 vss_1v2.n18 vss_1v2.n1451 8.5005
R2305 vss_1v2.n18 vss_1v2.n1342 8.5005
R2306 vss_1v2.n18 vss_1v2.n1450 8.5005
R2307 vss_1v2.n18 vss_1v2.n1343 8.5005
R2308 vss_1v2.n18 vss_1v2.n1449 8.5005
R2309 vss_1v2.n18 vss_1v2.n398 4.24922
R2310 vss_1v2.n18 vss_1v2.n1344 8.5005
R2311 vss_1v2.n18 vss_1v2.n1448 8.5005
R2312 vss_1v2.n18 vss_1v2.n1345 8.5005
R2313 vss_1v2.n18 vss_1v2.n1447 8.5005
R2314 vss_1v2.n18 vss_1v2.n1346 8.5005
R2315 vss_1v2.n18 vss_1v2.n410 4.24922
R2316 vss_1v2.n18 vss_1v2.n1446 8.5005
R2317 vss_1v2.n18 vss_1v2.n1347 8.5005
R2318 vss_1v2.n18 vss_1v2.n1445 8.5005
R2319 vss_1v2.n18 vss_1v2.n1348 8.5005
R2320 vss_1v2.n18 vss_1v2.n1444 8.5005
R2321 vss_1v2.n18 vss_1v2.n1349 8.5005
R2322 vss_1v2.n18 vss_1v2.n1443 8.5005
R2323 vss_1v2.n18 vss_1v2.n1350 8.5005
R2324 vss_1v2.n18 vss_1v2.n1442 8.5005
R2325 vss_1v2.n18 vss_1v2.n1351 8.5005
R2326 vss_1v2.n18 vss_1v2.n1441 8.5005
R2327 vss_1v2.n18 vss_1v2.n1352 8.5005
R2328 vss_1v2.n18 vss_1v2.n1440 8.5005
R2329 vss_1v2.n18 vss_1v2.n1353 8.5005
R2330 vss_1v2.n18 vss_1v2.n1439 8.5005
R2331 vss_1v2.n18 vss_1v2.n401 4.24922
R2332 vss_1v2.n18 vss_1v2.n1354 8.5005
R2333 vss_1v2.n18 vss_1v2.n1438 8.5005
R2334 vss_1v2.n18 vss_1v2.n1355 8.5005
R2335 vss_1v2.n18 vss_1v2.n1437 8.5005
R2336 vss_1v2.n18 vss_1v2.n1356 8.5005
R2337 vss_1v2.n18 vss_1v2.n413 4.24922
R2338 vss_1v2.n18 vss_1v2.n1436 8.5005
R2339 vss_1v2.n18 vss_1v2.n1357 8.5005
R2340 vss_1v2.n18 vss_1v2.n1435 8.5005
R2341 vss_1v2.n18 vss_1v2.n1358 8.5005
R2342 vss_1v2.n18 vss_1v2.n1434 8.5005
R2343 vss_1v2.n18 vss_1v2.n1359 8.5005
R2344 vss_1v2.n18 vss_1v2.n1433 8.5005
R2345 vss_1v2.n18 vss_1v2.n1360 8.5005
R2346 vss_1v2.n18 vss_1v2.n1432 8.5005
R2347 vss_1v2.n18 vss_1v2.n1361 8.5005
R2348 vss_1v2.n18 vss_1v2.n1431 8.5005
R2349 vss_1v2.n18 vss_1v2.n1362 8.5005
R2350 vss_1v2.n18 vss_1v2.n1430 8.5005
R2351 vss_1v2.n18 vss_1v2.n1363 8.5005
R2352 vss_1v2.n18 vss_1v2.n1429 8.5005
R2353 vss_1v2.n18 vss_1v2.n404 4.24922
R2354 vss_1v2.n18 vss_1v2.n1364 8.5005
R2355 vss_1v2.n18 vss_1v2.n1428 8.5005
R2356 vss_1v2.n18 vss_1v2.n1365 8.5005
R2357 vss_1v2.n18 vss_1v2.n1427 8.5005
R2358 vss_1v2.n18 vss_1v2.n1366 8.5005
R2359 vss_1v2.n18 vss_1v2.n416 4.24922
R2360 vss_1v2.n18 vss_1v2.n1426 8.5005
R2361 vss_1v2.n18 vss_1v2.n1367 8.5005
R2362 vss_1v2.n18 vss_1v2.n1425 8.5005
R2363 vss_1v2.n18 vss_1v2.n1368 8.5005
R2364 vss_1v2.n18 vss_1v2.n1424 8.5005
R2365 vss_1v2.n18 vss_1v2.n1369 8.5005
R2366 vss_1v2.n18 vss_1v2.n1423 8.5005
R2367 vss_1v2.n18 vss_1v2.n380 4.24936
R2368 vss_1v2.n18 vss_1v2.n1370 8.5005
R2369 vss_1v2.n18 vss_1v2.n1422 8.5005
R2370 vss_1v2.n18 vss_1v2.n1371 8.5005
R2371 vss_1v2.n18 vss_1v2.n1421 8.5005
R2372 vss_1v2.n18 vss_1v2.n1372 8.5005
R2373 vss_1v2.n18 vss_1v2.n390 4.24936
R2374 vss_1v2.n18 vss_1v2.n1420 8.5005
R2375 vss_1v2.n18 vss_1v2.n1373 8.5005
R2376 vss_1v2.n18 vss_1v2.n1419 8.5005
R2377 vss_1v2.n18 vss_1v2.n1374 8.5005
R2378 vss_1v2.n18 vss_1v2.n1418 8.5005
R2379 vss_1v2.n18 vss_1v2.n1375 8.5005
R2380 vss_1v2.n18 vss_1v2.n1417 8.5005
R2381 vss_1v2.n18 vss_1v2.n1376 8.5005
R2382 vss_1v2.n18 vss_1v2.n1416 8.5005
R2383 vss_1v2.n18 vss_1v2.n1377 8.5005
R2384 vss_1v2.n18 vss_1v2.n1415 8.5005
R2385 vss_1v2.n18 vss_1v2.n1378 8.5005
R2386 vss_1v2.n18 vss_1v2.n1414 8.5005
R2387 vss_1v2.n18 vss_1v2.n1379 8.5005
R2388 vss_1v2.n18 vss_1v2.n1413 8.5005
R2389 vss_1v2.n18 vss_1v2.n383 4.24936
R2390 vss_1v2.n18 vss_1v2.n1380 8.5005
R2391 vss_1v2.n18 vss_1v2.n1412 8.5005
R2392 vss_1v2.n18 vss_1v2.n1381 8.5005
R2393 vss_1v2.n18 vss_1v2.n1411 8.5005
R2394 vss_1v2.n18 vss_1v2.n1382 8.5005
R2395 vss_1v2.n18 vss_1v2.n393 4.24936
R2396 vss_1v2.n18 vss_1v2.n1410 8.5005
R2397 vss_1v2.n18 vss_1v2.n1383 8.5005
R2398 vss_1v2.n18 vss_1v2.n1409 8.5005
R2399 vss_1v2.n18 vss_1v2.n1384 8.5005
R2400 vss_1v2.n18 vss_1v2.n1408 8.5005
R2401 vss_1v2.n18 vss_1v2.n1385 8.5005
R2402 vss_1v2.n18 vss_1v2.n1407 8.5005
R2403 vss_1v2.n18 vss_1v2.n1386 8.5005
R2404 vss_1v2.n18 vss_1v2.n1406 8.5005
R2405 vss_1v2.n18 vss_1v2.n1387 8.5005
R2406 vss_1v2.n18 vss_1v2.n1405 8.5005
R2407 vss_1v2.n18 vss_1v2.n1388 8.5005
R2408 vss_1v2.n18 vss_1v2.n1404 8.5005
R2409 vss_1v2.n18 vss_1v2.n1389 8.5005
R2410 vss_1v2.n18 vss_1v2.n1403 8.5005
R2411 vss_1v2.n18 vss_1v2.n386 4.24936
R2412 vss_1v2.n18 vss_1v2.n1390 8.5005
R2413 vss_1v2.n18 vss_1v2.n1402 8.5005
R2414 vss_1v2.n18 vss_1v2.n1391 8.5005
R2415 vss_1v2.n18 vss_1v2.n1401 8.5005
R2416 vss_1v2.n18 vss_1v2.n1392 8.5005
R2417 vss_1v2.n18 vss_1v2.n1400 8.5005
R2418 vss_1v2.n18 vss_1v2.n1393 8.5005
R2419 vss_1v2.n18 vss_1v2.n1399 8.5005
R2420 vss_1v2.n18 vss_1v2.n1394 8.5005
R2421 vss_1v2.n18 vss_1v2.n1398 8.5005
R2422 vss_1v2.n18 vss_1v2.n1395 8.5005
R2423 vss_1v2.n18 vss_1v2.n1397 8.5005
R2424 vss_1v2.n17 vss_1v2.n18 0.0758534
R2425 vss_1v2.n199 vss_1v2.n18 2.82503
R2426 vss_1v2.n193 vss_1v2.n18 4.24817
R2427 vss_1v2.n188 vss_1v2.n18 4.25056
R2428 vss_1v2.n182 vss_1v2.n18 4.24634
R2429 vss_1v2.n171 vss_1v2.n18 4.24585
R2430 vss_1v2.n161 vss_1v2.n16 1.40656
R2431 vss_1v2.n160 vss_1v2.n18 4.24728
R2432 vss_1v2.n150 vss_1v2.n18 2.09471
R2433 vss_1v2.n149 vss_1v2.n18 4.24988
R2434 vss_1v2.n68 vss_1v2.n18 4.24633
R2435 vss_1v2.n66 vss_1v2.n18 2.78784
R2436 vss_1v2.n65 vss_1v2.n18 4.23808
R2437 vss_1v2.n146 vss_1v2.n16 1.38596
R2438 vss_1v2.n135 vss_1v2.n18 2.08581
R2439 vss_1v2.n129 vss_1v2.n18 2.83358
R2440 vss_1v2.n118 vss_1v2.n18 2.83391
R2441 vss_1v2.n113 vss_1v2.n18 1.3606
R2442 vss_1v2.n108 vss_1v2.n2 0.918808
R2443 vss_1v2.n98 vss_1v2.n18 8.5005
R2444 vss_1v2.n97 vss_1v2.n16 2.10552
R2445 vss_1v2.n94 vss_1v2.n18 8.5005
R2446 vss_1v2.n91 vss_1v2.n18 2.83009
R2447 vss_1v2.n88 vss_1v2.n18 8.5005
R2448 vss_1v2.n4135 vss_1v2.n938 8.5005
R2449 vss_1v2.n4135 vss_1v2.n940 8.5005
R2450 vss_1v2.n4135 vss_1v2.n1219 8.5005
R2451 vss_1v2.n4135 vss_1v2.n953 8.5005
R2452 vss_1v2.n4136 vss_1v2.n4135 8.5005
R2453 vss_1v2.n4135 vss_1v2.n1216 8.5005
R2454 vss_1v2.n4135 vss_1v2.n957 8.5005
R2455 vss_1v2.n4135 vss_1v2.n1214 8.5005
R2456 vss_1v2.n4135 vss_1v2.n959 8.5005
R2457 vss_1v2.n4135 vss_1v2.n1057 8.5005
R2458 vss_1v2.n4135 vss_1v2.n961 8.5005
R2459 vss_1v2.n4135 vss_1v2.n1055 8.5005
R2460 vss_1v2.n4135 vss_1v2.n963 8.5005
R2461 vss_1v2.n4135 vss_1v2.n1053 8.5005
R2462 vss_1v2.n4135 vss_1v2.n965 8.5005
R2463 vss_1v2.n4135 vss_1v2.n1051 8.5005
R2464 vss_1v2.n4135 vss_1v2.n966 8.5005
R2465 vss_1v2.n4135 vss_1v2.n1049 8.5005
R2466 vss_1v2.n4135 vss_1v2.n968 8.5005
R2467 vss_1v2.n4135 vss_1v2.n1047 8.5005
R2468 vss_1v2.n4135 vss_1v2.n970 8.5005
R2469 vss_1v2.n4135 vss_1v2.n1045 8.5005
R2470 vss_1v2.n4135 vss_1v2.n972 8.5005
R2471 vss_1v2.n4135 vss_1v2.n1043 8.5005
R2472 vss_1v2.n4135 vss_1v2.n974 8.5005
R2473 vss_1v2.n4135 vss_1v2.n1041 8.5005
R2474 vss_1v2.n4135 vss_1v2.n976 8.5005
R2475 vss_1v2.n4135 vss_1v2.n1039 8.5005
R2476 vss_1v2.n4135 vss_1v2.n1037 8.5005
R2477 vss_1v2.n4135 vss_1v2.n980 8.5005
R2478 vss_1v2.n4135 vss_1v2.n1035 8.5005
R2479 vss_1v2.n4135 vss_1v2.n982 8.5005
R2480 vss_1v2.n4135 vss_1v2.n1033 8.5005
R2481 vss_1v2.n4135 vss_1v2.n984 8.5005
R2482 vss_1v2.n4135 vss_1v2.n1031 8.5005
R2483 vss_1v2.n4135 vss_1v2.n986 8.5005
R2484 vss_1v2.n4135 vss_1v2.n1029 8.5005
R2485 vss_1v2.n4135 vss_1v2.n988 8.5005
R2486 vss_1v2.n4135 vss_1v2.n1028 8.5005
R2487 vss_1v2.n4135 vss_1v2.n989 8.5005
R2488 vss_1v2.n4135 vss_1v2.n1027 8.5005
R2489 vss_1v2.n4135 vss_1v2.n990 8.5005
R2490 vss_1v2.n4135 vss_1v2.n1026 8.5005
R2491 vss_1v2.n4135 vss_1v2.n991 8.5005
R2492 vss_1v2.n4135 vss_1v2.n1025 8.5005
R2493 vss_1v2.n4135 vss_1v2.n992 8.5005
R2494 vss_1v2.n4135 vss_1v2.n1024 8.5005
R2495 vss_1v2.n4135 vss_1v2.n993 8.5005
R2496 vss_1v2.n4135 vss_1v2.n1023 8.5005
R2497 vss_1v2.n4135 vss_1v2.n994 8.5005
R2498 vss_1v2.n4135 vss_1v2.n1022 8.5005
R2499 vss_1v2.n4135 vss_1v2.n995 8.5005
R2500 vss_1v2.n4135 vss_1v2.n1021 8.5005
R2501 vss_1v2.n4135 vss_1v2.n996 8.5005
R2502 vss_1v2.n4135 vss_1v2.n1020 8.5005
R2503 vss_1v2.n4135 vss_1v2.n997 8.5005
R2504 vss_1v2.n4135 vss_1v2.n1019 8.5005
R2505 vss_1v2.n4135 vss_1v2.n998 8.5005
R2506 vss_1v2.n4135 vss_1v2.n1018 8.5005
R2507 vss_1v2.n4135 vss_1v2.n999 8.5005
R2508 vss_1v2.n4135 vss_1v2.n1017 8.5005
R2509 vss_1v2.n4135 vss_1v2.n494 8.5005
R2510 vss_1v2.n4135 vss_1v2.n495 8.5005
R2511 vss_1v2.n4135 vss_1v2.n1001 8.5005
R2512 vss_1v2.n4135 vss_1v2.n1016 8.5005
R2513 vss_1v2.n4135 vss_1v2.n1002 8.5005
R2514 vss_1v2.n4135 vss_1v2.n1015 8.5005
R2515 vss_1v2.n4135 vss_1v2.n1003 8.5005
R2516 vss_1v2.n4135 vss_1v2.n1014 8.5005
R2517 vss_1v2.n4135 vss_1v2.n1004 8.5005
R2518 vss_1v2.n4135 vss_1v2.n1013 8.5005
R2519 vss_1v2.n4135 vss_1v2.n1005 8.5005
R2520 vss_1v2.n4135 vss_1v2.n1012 8.5005
R2521 vss_1v2.n4135 vss_1v2.n1006 8.5005
R2522 vss_1v2.n4135 vss_1v2.n1011 8.5005
R2523 vss_1v2.n4135 vss_1v2.n4134 8.5005
R2524 vss_1v2.n4135 vss_1v2.n949 8.5005
R2525 vss_1v2.n4135 vss_1v2.n1218 8.5005
R2526 vss_1v2.n4135 vss_1v2.n954 8.5005
R2527 vss_1v2.n4135 vss_1v2.n1217 8.5005
R2528 vss_1v2.n4135 vss_1v2.n956 8.5005
R2529 vss_1v2.n4135 vss_1v2.n955 8.5005
R2530 vss_1v2.n4135 vss_1v2.n1215 8.5005
R2531 vss_1v2.n4135 vss_1v2.n958 8.5005
R2532 vss_1v2.n4135 vss_1v2.n1058 8.5005
R2533 vss_1v2.n4135 vss_1v2.n960 8.5005
R2534 vss_1v2.n4135 vss_1v2.n1056 8.5005
R2535 vss_1v2.n4135 vss_1v2.n962 8.5005
R2536 vss_1v2.n4135 vss_1v2.n1054 8.5005
R2537 vss_1v2.n4135 vss_1v2.n964 8.5005
R2538 vss_1v2.n4135 vss_1v2.n1052 8.5005
R2539 vss_1v2.n4135 vss_1v2.t276 8.5005
R2540 vss_1v2.n4135 vss_1v2.n1050 8.5005
R2541 vss_1v2.n4135 vss_1v2.n967 8.5005
R2542 vss_1v2.n4135 vss_1v2.n1048 8.5005
R2543 vss_1v2.n4135 vss_1v2.n969 8.5005
R2544 vss_1v2.n4135 vss_1v2.n1046 8.5005
R2545 vss_1v2.n4135 vss_1v2.n971 8.5005
R2546 vss_1v2.n4135 vss_1v2.n1044 8.5005
R2547 vss_1v2.n4135 vss_1v2.n973 8.5005
R2548 vss_1v2.n4135 vss_1v2.n1042 8.5005
R2549 vss_1v2.n4135 vss_1v2.n975 8.5005
R2550 vss_1v2.n4135 vss_1v2.n1040 8.5005
R2551 vss_1v2.n4135 vss_1v2.n977 8.5005
R2552 vss_1v2.n4135 vss_1v2.n1038 8.5005
R2553 vss_1v2.n4135 vss_1v2.n979 8.5005
R2554 vss_1v2.n4135 vss_1v2.n978 8.5005
R2555 vss_1v2.n4135 vss_1v2.n1036 8.5005
R2556 vss_1v2.n4135 vss_1v2.n981 8.5005
R2557 vss_1v2.n4135 vss_1v2.n1034 8.5005
R2558 vss_1v2.n4135 vss_1v2.n983 8.5005
R2559 vss_1v2.n4135 vss_1v2.n1032 8.5005
R2560 vss_1v2.n4135 vss_1v2.n985 8.5005
R2561 vss_1v2.n4135 vss_1v2.n1030 8.5005
R2562 vss_1v2.n4135 vss_1v2.n987 8.5005
R2563 vss_1v2.n4135 vss_1v2.n223 8.5005
R2564 vss_1v2.n4135 vss_1v2.n224 8.5005
R2565 vss_1v2.n4135 vss_1v2.n225 8.5005
R2566 vss_1v2.n4135 vss_1v2.n226 8.5005
R2567 vss_1v2.n4135 vss_1v2.n227 8.5005
R2568 vss_1v2.n4135 vss_1v2.n228 8.5005
R2569 vss_1v2.n4135 vss_1v2.n229 8.5005
R2570 vss_1v2.n4135 vss_1v2.n230 8.5005
R2571 vss_1v2.n4135 vss_1v2.n231 8.5005
R2572 vss_1v2.n4135 vss_1v2.n232 8.5005
R2573 vss_1v2.n4135 vss_1v2.n233 8.5005
R2574 vss_1v2.n4135 vss_1v2.n234 8.5005
R2575 vss_1v2.n4135 vss_1v2.n235 8.5005
R2576 vss_1v2.n4135 vss_1v2.n236 8.5005
R2577 vss_1v2.n4135 vss_1v2.n237 8.5005
R2578 vss_1v2.n4135 vss_1v2.n238 8.5005
R2579 vss_1v2.n4135 vss_1v2.n239 8.5005
R2580 vss_1v2.n4135 vss_1v2.n240 8.5005
R2581 vss_1v2.n4135 vss_1v2.n241 8.5005
R2582 vss_1v2.n4135 vss_1v2.n242 8.5005
R2583 vss_1v2.n4135 vss_1v2.n243 8.5005
R2584 vss_1v2.n4135 vss_1v2.n244 8.5005
R2585 vss_1v2.n4135 vss_1v2.n245 8.5005
R2586 vss_1v2.n4135 vss_1v2.n246 8.5005
R2587 vss_1v2.n4135 vss_1v2.n247 8.5005
R2588 vss_1v2.n4135 vss_1v2.n248 8.5005
R2589 vss_1v2.n4135 vss_1v2.n249 8.5005
R2590 vss_1v2.n4135 vss_1v2.n250 8.5005
R2591 vss_1v2.n4135 vss_1v2.n251 8.5005
R2592 vss_1v2.n4135 vss_1v2.n252 8.5005
R2593 vss_1v2.n4135 vss_1v2.n253 8.5005
R2594 vss_1v2.n4135 vss_1v2.n254 8.5005
R2595 vss_1v2.n4135 vss_1v2.n255 8.5005
R2596 vss_1v2.n4135 vss_1v2.n256 8.5005
R2597 vss_1v2.n4135 vss_1v2.n257 8.5005
R2598 vss_1v2.n4135 vss_1v2.n258 8.5005
R2599 vss_1v2.n4135 vss_1v2.n259 8.5005
R2600 vss_1v2.n4135 vss_1v2.n1007 8.5005
R2601 vss_1v2.n4135 vss_1v2.n4 8.5005
R2602 vss_1v2.n4133 vss_1v2.n4132 8.5005
R2603 vss_1v2.n4135 vss_1v2.n939 8.5005
R2604 vss_1v2.n3314 vss_1v2.n2658 8.5005
R2605 vss_1v2.n3317 vss_1v2.n3316 8.5005
R2606 vss_1v2.n3323 vss_1v2.n3322 8.5005
R2607 vss_1v2.n4133 vss_1v2.n1274 8.5005
R2608 vss_1v2.n4134 vss_1v2.n4133 8.5005
R2609 vss_1v2.n4133 vss_1v2.n1223 8.5005
R2610 vss_1v2.n4133 vss_1v2.n1227 8.5005
R2611 vss_1v2.n4133 vss_1v2.n222 8.5005
R2612 vss_1v2.n3209 vss_1v2.n2979 8.5005
R2613 vss_1v2.n3209 vss_1v2.n1223 8.5005
R2614 vss_1v2.n3209 vss_1v2.n1227 8.5005
R2615 vss_1v2.n3209 vss_1v2.n1299 8.5005
R2616 vss_1v2.n3209 vss_1v2.n1300 8.5005
R2617 vss_1v2.n3209 vss_1v2.n1304 8.5005
R2618 vss_1v2.n3209 vss_1v2.n1305 8.5005
R2619 vss_1v2.n3209 vss_1v2.n1306 8.5005
R2620 vss_1v2.n3209 vss_1v2.n1307 8.5005
R2621 vss_1v2.n3209 vss_1v2.n1308 8.5005
R2622 vss_1v2.n3209 vss_1v2.n1309 8.5005
R2623 vss_1v2.n3209 vss_1v2.n1310 8.5005
R2624 vss_1v2.n3209 vss_1v2.n1311 8.5005
R2625 vss_1v2.n3209 vss_1v2.n1312 8.5005
R2626 vss_1v2.n3209 vss_1v2.n1313 8.5005
R2627 vss_1v2.n3209 vss_1v2.n1314 8.5005
R2628 vss_1v2.n3209 vss_1v2.n221 8.5005
R2629 vss_1v2.n3209 vss_1v2.n1315 8.5005
R2630 vss_1v2.n3209 vss_1v2.n1316 8.5005
R2631 vss_1v2.n3209 vss_1v2.n1317 8.5005
R2632 vss_1v2.n3209 vss_1v2.n1318 8.5005
R2633 vss_1v2.n3209 vss_1v2.n1319 8.5005
R2634 vss_1v2.n3209 vss_1v2.n1320 8.5005
R2635 vss_1v2.n3209 vss_1v2.n1321 8.5005
R2636 vss_1v2.n3209 vss_1v2.n1322 8.5005
R2637 vss_1v2.n3209 vss_1v2.n1323 8.5005
R2638 vss_1v2.n3209 vss_1v2.n1324 8.5005
R2639 vss_1v2.n3209 vss_1v2.n1325 8.5005
R2640 vss_1v2.n3209 vss_1v2.n1326 8.5005
R2641 vss_1v2.n3209 vss_1v2.n1327 8.5005
R2642 vss_1v2.n3209 vss_1v2.n1328 8.5005
R2643 vss_1v2.n3209 vss_1v2.n1329 8.5005
R2644 vss_1v2.n3209 vss_1v2.n1330 8.5005
R2645 vss_1v2.n3209 vss_1v2.n1331 8.5005
R2646 vss_1v2.n3209 vss_1v2.n1332 8.5005
R2647 vss_1v2.n3209 vss_1v2.n1333 8.5005
R2648 vss_1v2.n3209 vss_1v2.n1334 8.5005
R2649 vss_1v2.n3209 vss_1v2.n1335 8.5005
R2650 vss_1v2.n3209 vss_1v2.n1336 8.5005
R2651 vss_1v2.n3209 vss_1v2.n222 8.5005
R2652 vss_1v2.n3209 vss_1v2.n223 8.5005
R2653 vss_1v2.n3209 vss_1v2.n224 8.5005
R2654 vss_1v2.n3209 vss_1v2.n225 8.5005
R2655 vss_1v2.n3209 vss_1v2.n226 8.5005
R2656 vss_1v2.n3209 vss_1v2.n227 8.5005
R2657 vss_1v2.n3209 vss_1v2.n228 8.5005
R2658 vss_1v2.n3209 vss_1v2.n229 8.5005
R2659 vss_1v2.n3209 vss_1v2.n230 8.5005
R2660 vss_1v2.n3209 vss_1v2.n231 8.5005
R2661 vss_1v2.n3209 vss_1v2.n232 8.5005
R2662 vss_1v2.n3209 vss_1v2.n233 8.5005
R2663 vss_1v2.n3209 vss_1v2.n234 8.5005
R2664 vss_1v2.n3209 vss_1v2.n235 8.5005
R2665 vss_1v2.n3209 vss_1v2.n236 8.5005
R2666 vss_1v2.n3209 vss_1v2.n237 8.5005
R2667 vss_1v2.n3209 vss_1v2.n238 8.5005
R2668 vss_1v2.n3209 vss_1v2.n239 8.5005
R2669 vss_1v2.n3209 vss_1v2.n240 8.5005
R2670 vss_1v2.n3209 vss_1v2.n241 8.5005
R2671 vss_1v2.n3209 vss_1v2.n242 8.5005
R2672 vss_1v2.n3209 vss_1v2.n243 8.5005
R2673 vss_1v2.n3209 vss_1v2.n244 8.5005
R2674 vss_1v2.n3209 vss_1v2.n245 8.5005
R2675 vss_1v2.n3209 vss_1v2.n246 8.5005
R2676 vss_1v2.n3209 vss_1v2.n247 8.5005
R2677 vss_1v2.n3209 vss_1v2.n248 8.5005
R2678 vss_1v2.n3209 vss_1v2.n249 8.5005
R2679 vss_1v2.n3209 vss_1v2.n250 8.5005
R2680 vss_1v2.n3209 vss_1v2.n251 8.5005
R2681 vss_1v2.n3209 vss_1v2.n252 8.5005
R2682 vss_1v2.n3209 vss_1v2.n253 8.5005
R2683 vss_1v2.n3209 vss_1v2.n254 8.5005
R2684 vss_1v2.n3209 vss_1v2.n255 8.5005
R2685 vss_1v2.n3209 vss_1v2.n256 8.5005
R2686 vss_1v2.n3209 vss_1v2.n257 8.5005
R2687 vss_1v2.n3209 vss_1v2.n258 8.5005
R2688 vss_1v2.n3209 vss_1v2.n259 8.5005
R2689 vss_1v2.n3209 vss_1v2.n1007 8.5005
R2690 vss_1v2.n3209 vss_1v2.n4 8.5005
R2691 vss_1v2.n4133 vss_1v2.n1225 8.5005
R2692 vss_1v2.n3240 vss_1v2.n3239 8.5005
R2693 vss_1v2.n3236 vss_1v2.n3223 8.5005
R2694 vss_1v2.n3234 vss_1v2.n3233 8.5005
R2695 vss_1v2.n3232 vss_1v2.n3231 8.5005
R2696 vss_1v2.n3216 vss_1v2.n3215 8.5005
R2697 vss_1v2.n3213 vss_1v2.n3212 8.5005
R2698 vss_1v2.n3209 vss_1v2.n2981 8.5005
R2699 vss_1v2.n3165 vss_1v2.n3164 8.5005
R2700 vss_1v2.n3134 vss_1v2.n3133 8.5005
R2701 vss_1v2.n3145 vss_1v2.n3144 8.5005
R2702 vss_1v2.n3128 vss_1v2.n2828 8.5005
R2703 vss_1v2.n3558 vss_1v2.n2828 8.5005
R2704 vss_1v2.n2828 vss_1v2.n1223 8.5005
R2705 vss_1v2.n2828 vss_1v2.n1227 8.5005
R2706 vss_1v2.n2828 vss_1v2.n1299 8.5005
R2707 vss_1v2.n2828 vss_1v2.n1300 8.5005
R2708 vss_1v2.n2828 vss_1v2.n1304 8.5005
R2709 vss_1v2.n2828 vss_1v2.n1305 8.5005
R2710 vss_1v2.n2828 vss_1v2.n1306 8.5005
R2711 vss_1v2.n2828 vss_1v2.n1307 8.5005
R2712 vss_1v2.n2828 vss_1v2.n1308 8.5005
R2713 vss_1v2.n2828 vss_1v2.n1309 8.5005
R2714 vss_1v2.n2828 vss_1v2.n1310 8.5005
R2715 vss_1v2.n2828 vss_1v2.n1311 8.5005
R2716 vss_1v2.n2828 vss_1v2.n1312 8.5005
R2717 vss_1v2.n2828 vss_1v2.n1313 8.5005
R2718 vss_1v2.n2828 vss_1v2.n1314 8.5005
R2719 vss_1v2.n2828 vss_1v2.n221 8.5005
R2720 vss_1v2.n2828 vss_1v2.n1315 8.5005
R2721 vss_1v2.n2828 vss_1v2.n1316 8.5005
R2722 vss_1v2.n2828 vss_1v2.n1317 8.5005
R2723 vss_1v2.n2828 vss_1v2.n1318 8.5005
R2724 vss_1v2.n2828 vss_1v2.n1319 8.5005
R2725 vss_1v2.n2828 vss_1v2.n1320 8.5005
R2726 vss_1v2.n2828 vss_1v2.n1321 8.5005
R2727 vss_1v2.n2828 vss_1v2.n1322 8.5005
R2728 vss_1v2.n2828 vss_1v2.n1323 8.5005
R2729 vss_1v2.n2828 vss_1v2.n1324 8.5005
R2730 vss_1v2.n2828 vss_1v2.n1325 8.5005
R2731 vss_1v2.n2828 vss_1v2.n1326 8.5005
R2732 vss_1v2.n2828 vss_1v2.n1327 8.5005
R2733 vss_1v2.n2828 vss_1v2.n1328 8.5005
R2734 vss_1v2.n2828 vss_1v2.n1329 8.5005
R2735 vss_1v2.n2828 vss_1v2.n1330 8.5005
R2736 vss_1v2.n2828 vss_1v2.n1331 8.5005
R2737 vss_1v2.n2828 vss_1v2.n1332 8.5005
R2738 vss_1v2.n2828 vss_1v2.n1333 8.5005
R2739 vss_1v2.n2828 vss_1v2.n1334 8.5005
R2740 vss_1v2.n2828 vss_1v2.n1335 8.5005
R2741 vss_1v2.n2828 vss_1v2.n1336 8.5005
R2742 vss_1v2.n2828 vss_1v2.n222 8.5005
R2743 vss_1v2.n2828 vss_1v2.n223 8.5005
R2744 vss_1v2.n2828 vss_1v2.n224 8.5005
R2745 vss_1v2.n2828 vss_1v2.n225 8.5005
R2746 vss_1v2.n2828 vss_1v2.n226 8.5005
R2747 vss_1v2.n2828 vss_1v2.n227 8.5005
R2748 vss_1v2.n2828 vss_1v2.n228 8.5005
R2749 vss_1v2.n2828 vss_1v2.n229 8.5005
R2750 vss_1v2.n2828 vss_1v2.n230 8.5005
R2751 vss_1v2.n2828 vss_1v2.n231 8.5005
R2752 vss_1v2.n2828 vss_1v2.n232 8.5005
R2753 vss_1v2.n2828 vss_1v2.n233 8.5005
R2754 vss_1v2.n2828 vss_1v2.n234 8.5005
R2755 vss_1v2.n2828 vss_1v2.n235 8.5005
R2756 vss_1v2.n2828 vss_1v2.n236 8.5005
R2757 vss_1v2.n2828 vss_1v2.n237 8.5005
R2758 vss_1v2.n2828 vss_1v2.n238 8.5005
R2759 vss_1v2.n2828 vss_1v2.n239 8.5005
R2760 vss_1v2.n2828 vss_1v2.n240 8.5005
R2761 vss_1v2.n2828 vss_1v2.n241 8.5005
R2762 vss_1v2.n2828 vss_1v2.n242 8.5005
R2763 vss_1v2.n2828 vss_1v2.n243 8.5005
R2764 vss_1v2.n2828 vss_1v2.n244 8.5005
R2765 vss_1v2.n2828 vss_1v2.n245 8.5005
R2766 vss_1v2.n2828 vss_1v2.n246 8.5005
R2767 vss_1v2.n2828 vss_1v2.n247 8.5005
R2768 vss_1v2.n2828 vss_1v2.n248 8.5005
R2769 vss_1v2.n2828 vss_1v2.n249 8.5005
R2770 vss_1v2.n2828 vss_1v2.n250 8.5005
R2771 vss_1v2.n2828 vss_1v2.n251 8.5005
R2772 vss_1v2.n2828 vss_1v2.n252 8.5005
R2773 vss_1v2.n2828 vss_1v2.n253 8.5005
R2774 vss_1v2.n2828 vss_1v2.n254 8.5005
R2775 vss_1v2.n2828 vss_1v2.n255 8.5005
R2776 vss_1v2.n2828 vss_1v2.n256 8.5005
R2777 vss_1v2.n2828 vss_1v2.n257 8.5005
R2778 vss_1v2.n2828 vss_1v2.n258 8.5005
R2779 vss_1v2.n2828 vss_1v2.n259 8.5005
R2780 vss_1v2.n2828 vss_1v2.n1007 8.5005
R2781 vss_1v2.n2828 vss_1v2.n4 8.5005
R2782 vss_1v2.n4132 vss_1v2.n1295 8.5005
R2783 vss_1v2.n3062 vss_1v2.n1295 8.5005
R2784 vss_1v2.n1295 vss_1v2.n1223 8.5005
R2785 vss_1v2.n1295 vss_1v2.n1227 8.5005
R2786 vss_1v2.n1299 vss_1v2.n1295 8.5005
R2787 vss_1v2.n1300 vss_1v2.n1295 8.5005
R2788 vss_1v2.n1304 vss_1v2.n1295 8.5005
R2789 vss_1v2.n1305 vss_1v2.n1295 8.5005
R2790 vss_1v2.n1306 vss_1v2.n1295 8.5005
R2791 vss_1v2.n1307 vss_1v2.n1295 8.5005
R2792 vss_1v2.n1308 vss_1v2.n1295 8.5005
R2793 vss_1v2.n1309 vss_1v2.n1295 8.5005
R2794 vss_1v2.n1310 vss_1v2.n1295 8.5005
R2795 vss_1v2.n1311 vss_1v2.n1295 8.5005
R2796 vss_1v2.n1312 vss_1v2.n1295 8.5005
R2797 vss_1v2.n1313 vss_1v2.n1295 8.5005
R2798 vss_1v2.n1314 vss_1v2.n1295 8.5005
R2799 vss_1v2.n1295 vss_1v2.n221 8.5005
R2800 vss_1v2.n1315 vss_1v2.n1295 8.5005
R2801 vss_1v2.n1316 vss_1v2.n1295 8.5005
R2802 vss_1v2.n1317 vss_1v2.n1295 8.5005
R2803 vss_1v2.n1318 vss_1v2.n1295 8.5005
R2804 vss_1v2.n1319 vss_1v2.n1295 8.5005
R2805 vss_1v2.n1320 vss_1v2.n1295 8.5005
R2806 vss_1v2.n1321 vss_1v2.n1295 8.5005
R2807 vss_1v2.n1322 vss_1v2.n1295 8.5005
R2808 vss_1v2.n1323 vss_1v2.n1295 8.5005
R2809 vss_1v2.n1324 vss_1v2.n1295 8.5005
R2810 vss_1v2.n1325 vss_1v2.n1295 8.5005
R2811 vss_1v2.n1326 vss_1v2.n1295 8.5005
R2812 vss_1v2.n1327 vss_1v2.n1295 8.5005
R2813 vss_1v2.n1328 vss_1v2.n1295 8.5005
R2814 vss_1v2.n1329 vss_1v2.n1295 8.5005
R2815 vss_1v2.n1330 vss_1v2.n1295 8.5005
R2816 vss_1v2.n1331 vss_1v2.n1295 8.5005
R2817 vss_1v2.n1332 vss_1v2.n1295 8.5005
R2818 vss_1v2.n1333 vss_1v2.n1295 8.5005
R2819 vss_1v2.n1334 vss_1v2.n1295 8.5005
R2820 vss_1v2.n1335 vss_1v2.n1295 8.5005
R2821 vss_1v2.n1336 vss_1v2.n1295 8.5005
R2822 vss_1v2.n1295 vss_1v2.n222 8.5005
R2823 vss_1v2.n1295 vss_1v2.n223 8.5005
R2824 vss_1v2.n1295 vss_1v2.n224 8.5005
R2825 vss_1v2.n1295 vss_1v2.n225 8.5005
R2826 vss_1v2.n1295 vss_1v2.n226 8.5005
R2827 vss_1v2.n1295 vss_1v2.n227 8.5005
R2828 vss_1v2.n1295 vss_1v2.n228 8.5005
R2829 vss_1v2.n1295 vss_1v2.n229 8.5005
R2830 vss_1v2.n1295 vss_1v2.n230 8.5005
R2831 vss_1v2.n1295 vss_1v2.n231 8.5005
R2832 vss_1v2.n1295 vss_1v2.n232 8.5005
R2833 vss_1v2.n1295 vss_1v2.n233 8.5005
R2834 vss_1v2.n1295 vss_1v2.n234 8.5005
R2835 vss_1v2.n1295 vss_1v2.n235 8.5005
R2836 vss_1v2.n1295 vss_1v2.n236 8.5005
R2837 vss_1v2.n1295 vss_1v2.n237 8.5005
R2838 vss_1v2.n1295 vss_1v2.n238 8.5005
R2839 vss_1v2.n1295 vss_1v2.n239 8.5005
R2840 vss_1v2.n1295 vss_1v2.n240 8.5005
R2841 vss_1v2.n1295 vss_1v2.n241 8.5005
R2842 vss_1v2.n1295 vss_1v2.n242 8.5005
R2843 vss_1v2.n1295 vss_1v2.n243 8.5005
R2844 vss_1v2.n1295 vss_1v2.n244 8.5005
R2845 vss_1v2.n1295 vss_1v2.n245 8.5005
R2846 vss_1v2.n1295 vss_1v2.n246 8.5005
R2847 vss_1v2.n1295 vss_1v2.n247 8.5005
R2848 vss_1v2.n1295 vss_1v2.n248 8.5005
R2849 vss_1v2.n1295 vss_1v2.n249 8.5005
R2850 vss_1v2.n1295 vss_1v2.n250 8.5005
R2851 vss_1v2.n1295 vss_1v2.n251 8.5005
R2852 vss_1v2.n1295 vss_1v2.n252 8.5005
R2853 vss_1v2.n1295 vss_1v2.n253 8.5005
R2854 vss_1v2.n1295 vss_1v2.n254 8.5005
R2855 vss_1v2.n1295 vss_1v2.n255 8.5005
R2856 vss_1v2.n1295 vss_1v2.n256 8.5005
R2857 vss_1v2.n1295 vss_1v2.n257 8.5005
R2858 vss_1v2.n1295 vss_1v2.n258 8.5005
R2859 vss_1v2.n1295 vss_1v2.n259 8.5005
R2860 vss_1v2.n1295 vss_1v2.n1007 8.5005
R2861 vss_1v2.n1295 vss_1v2.n4 8.5005
R2862 vss_1v2.n2898 vss_1v2.n2828 8.5005
R2863 vss_1v2.n2897 vss_1v2.n2896 8.5005
R2864 vss_1v2.n2890 vss_1v2.n2889 8.5005
R2865 vss_1v2.n3059 vss_1v2.n2882 8.5005
R2866 vss_1v2.n2881 vss_1v2.n3061 8.5005
R2867 vss_1v2.n3068 vss_1v2.n1295 8.5005
R2868 vss_1v2.n2689 vss_1v2.n2688 8.5005
R2869 vss_1v2.n3580 vss_1v2.n3579 8.5005
R2870 vss_1v2.n3561 vss_1v2.n3560 8.5005
R2871 vss_1v2.n2814 vss_1v2.n1965 8.5005
R2872 vss_1v2.n1965 vss_1v2.n1227 8.5005
R2873 vss_1v2.n1965 vss_1v2.n1299 8.5005
R2874 vss_1v2.n1965 vss_1v2.n1300 8.5005
R2875 vss_1v2.n1965 vss_1v2.n1304 8.5005
R2876 vss_1v2.n1965 vss_1v2.n1305 8.5005
R2877 vss_1v2.n1965 vss_1v2.n1306 8.5005
R2878 vss_1v2.n1965 vss_1v2.n1307 8.5005
R2879 vss_1v2.n1965 vss_1v2.n1308 8.5005
R2880 vss_1v2.n1965 vss_1v2.n1309 8.5005
R2881 vss_1v2.n1965 vss_1v2.n1310 8.5005
R2882 vss_1v2.n1965 vss_1v2.n1311 8.5005
R2883 vss_1v2.n1965 vss_1v2.n1312 8.5005
R2884 vss_1v2.n1965 vss_1v2.n1313 8.5005
R2885 vss_1v2.n1965 vss_1v2.n1314 8.5005
R2886 vss_1v2.n1965 vss_1v2.n221 8.5005
R2887 vss_1v2.n1965 vss_1v2.n1315 8.5005
R2888 vss_1v2.n1965 vss_1v2.n1316 8.5005
R2889 vss_1v2.n1965 vss_1v2.n1317 8.5005
R2890 vss_1v2.n1965 vss_1v2.n1318 8.5005
R2891 vss_1v2.n1965 vss_1v2.n1319 8.5005
R2892 vss_1v2.n1965 vss_1v2.n1320 8.5005
R2893 vss_1v2.n1965 vss_1v2.n1321 8.5005
R2894 vss_1v2.n1965 vss_1v2.n1322 8.5005
R2895 vss_1v2.n261 vss_1v2.n1323 4.25087
R2896 vss_1v2.n1965 vss_1v2.n1324 8.5005
R2897 vss_1v2.n1965 vss_1v2.n1325 8.5005
R2898 vss_1v2.n1965 vss_1v2.n1326 8.5005
R2899 vss_1v2.n1965 vss_1v2.n1327 8.5005
R2900 vss_1v2.n1965 vss_1v2.n1328 8.5005
R2901 vss_1v2.n1965 vss_1v2.n1329 8.5005
R2902 vss_1v2.n1965 vss_1v2.n1330 8.5005
R2903 vss_1v2.n1965 vss_1v2.n1331 8.5005
R2904 vss_1v2.n1965 vss_1v2.n1332 8.5005
R2905 vss_1v2.n1965 vss_1v2.n1333 8.5005
R2906 vss_1v2.n1965 vss_1v2.n1334 8.5005
R2907 vss_1v2.n1965 vss_1v2.n1335 8.5005
R2908 vss_1v2.n1965 vss_1v2.n1336 8.5005
R2909 vss_1v2.n1965 vss_1v2.n222 8.5005
R2910 vss_1v2.n1965 vss_1v2.n223 8.5005
R2911 vss_1v2.n1965 vss_1v2.n224 8.5005
R2912 vss_1v2.n1965 vss_1v2.n225 8.5005
R2913 vss_1v2.n1965 vss_1v2.n226 8.5005
R2914 vss_1v2.n1965 vss_1v2.n227 8.5005
R2915 vss_1v2.n1965 vss_1v2.n228 8.5005
R2916 vss_1v2.n1965 vss_1v2.n229 8.5005
R2917 vss_1v2.n1965 vss_1v2.n230 8.5005
R2918 vss_1v2.n1965 vss_1v2.n231 8.5005
R2919 vss_1v2.n1965 vss_1v2.n232 8.5005
R2920 vss_1v2.n1965 vss_1v2.n233 8.5005
R2921 vss_1v2.n1965 vss_1v2.n234 8.5005
R2922 vss_1v2.n1965 vss_1v2.n235 8.5005
R2923 vss_1v2.n1965 vss_1v2.n236 8.5005
R2924 vss_1v2.n1965 vss_1v2.n237 8.5005
R2925 vss_1v2.n1965 vss_1v2.n238 8.5005
R2926 vss_1v2.n1965 vss_1v2.n239 8.5005
R2927 vss_1v2.n1965 vss_1v2.n240 8.5005
R2928 vss_1v2.n1965 vss_1v2.n241 8.5005
R2929 vss_1v2.n1965 vss_1v2.n242 8.5005
R2930 vss_1v2.n1965 vss_1v2.n243 8.5005
R2931 vss_1v2.n1965 vss_1v2.n244 8.5005
R2932 vss_1v2.n1965 vss_1v2.n245 8.5005
R2933 vss_1v2.n1965 vss_1v2.n246 8.5005
R2934 vss_1v2.n1965 vss_1v2.n247 8.5005
R2935 vss_1v2.n1965 vss_1v2.n248 8.5005
R2936 vss_1v2.n1965 vss_1v2.n249 8.5005
R2937 vss_1v2.n1965 vss_1v2.n250 8.5005
R2938 vss_1v2.n1965 vss_1v2.n251 8.5005
R2939 vss_1v2.n1965 vss_1v2.n252 8.5005
R2940 vss_1v2.n1965 vss_1v2.n253 8.5005
R2941 vss_1v2.n1965 vss_1v2.n254 8.5005
R2942 vss_1v2.n1965 vss_1v2.n255 8.5005
R2943 vss_1v2.n1965 vss_1v2.n256 8.5005
R2944 vss_1v2.n1965 vss_1v2.n257 8.5005
R2945 vss_1v2.n1965 vss_1v2.n258 8.5005
R2946 vss_1v2.n1965 vss_1v2.n259 8.5005
R2947 vss_1v2.n1965 vss_1v2.n1007 8.5005
R2948 vss_1v2.n1301 vss_1v2.n1223 8.5005
R2949 vss_1v2.n260 vss_1v2.n1299 8.5005
R2950 vss_1v2.n260 vss_1v2.n1300 8.5005
R2951 vss_1v2.n260 vss_1v2.n1304 8.5005
R2952 vss_1v2.n260 vss_1v2.n1305 8.5005
R2953 vss_1v2.n260 vss_1v2.n1306 8.5005
R2954 vss_1v2.n260 vss_1v2.n1307 8.5005
R2955 vss_1v2.n260 vss_1v2.n1308 8.5005
R2956 vss_1v2.n260 vss_1v2.n1309 8.5005
R2957 vss_1v2.n260 vss_1v2.n1310 8.5005
R2958 vss_1v2.n260 vss_1v2.n1311 8.5005
R2959 vss_1v2.n260 vss_1v2.n1312 8.5005
R2960 vss_1v2.n260 vss_1v2.n1313 8.5005
R2961 vss_1v2.n260 vss_1v2.n1314 8.5005
R2962 vss_1v2.n260 vss_1v2.n221 8.5005
R2963 vss_1v2.n260 vss_1v2.n1315 8.5005
R2964 vss_1v2.n260 vss_1v2.n1316 8.5005
R2965 vss_1v2.n260 vss_1v2.n1317 8.5005
R2966 vss_1v2.n260 vss_1v2.n1318 8.5005
R2967 vss_1v2.n260 vss_1v2.n1319 8.5005
R2968 vss_1v2.n260 vss_1v2.n1320 8.5005
R2969 vss_1v2.n260 vss_1v2.n1321 8.5005
R2970 vss_1v2.n260 vss_1v2.n1322 8.5005
R2971 vss_1v2.n260 vss_1v2.n261 0.00124999
R2972 vss_1v2.n260 vss_1v2.n1324 8.5005
R2973 vss_1v2.n260 vss_1v2.n1325 8.5005
R2974 vss_1v2.n260 vss_1v2.n1326 8.5005
R2975 vss_1v2.n260 vss_1v2.n1327 8.5005
R2976 vss_1v2.n260 vss_1v2.n1328 8.5005
R2977 vss_1v2.n260 vss_1v2.n1329 8.5005
R2978 vss_1v2.n260 vss_1v2.n1330 8.5005
R2979 vss_1v2.n260 vss_1v2.n1331 8.5005
R2980 vss_1v2.n260 vss_1v2.n1332 8.5005
R2981 vss_1v2.n260 vss_1v2.n1333 8.5005
R2982 vss_1v2.n260 vss_1v2.n1334 8.5005
R2983 vss_1v2.n260 vss_1v2.n1335 8.5005
R2984 vss_1v2.n260 vss_1v2.n1336 8.5005
R2985 vss_1v2.n260 vss_1v2.n222 8.5005
R2986 vss_1v2.n260 vss_1v2.n223 8.5005
R2987 vss_1v2.n260 vss_1v2.n224 8.5005
R2988 vss_1v2.n260 vss_1v2.n225 8.5005
R2989 vss_1v2.n260 vss_1v2.n226 8.5005
R2990 vss_1v2.n260 vss_1v2.n227 8.5005
R2991 vss_1v2.n260 vss_1v2.n228 8.5005
R2992 vss_1v2.n260 vss_1v2.n229 8.5005
R2993 vss_1v2.n260 vss_1v2.n230 8.5005
R2994 vss_1v2.n260 vss_1v2.n231 8.5005
R2995 vss_1v2.n260 vss_1v2.n232 8.5005
R2996 vss_1v2.n260 vss_1v2.n233 8.5005
R2997 vss_1v2.n260 vss_1v2.n234 8.5005
R2998 vss_1v2.n260 vss_1v2.n235 8.5005
R2999 vss_1v2.n260 vss_1v2.n236 8.5005
R3000 vss_1v2.n260 vss_1v2.n237 8.5005
R3001 vss_1v2.n260 vss_1v2.n238 8.5005
R3002 vss_1v2.n260 vss_1v2.n239 8.5005
R3003 vss_1v2.n260 vss_1v2.n240 8.5005
R3004 vss_1v2.n260 vss_1v2.n241 8.5005
R3005 vss_1v2.n260 vss_1v2.n242 8.5005
R3006 vss_1v2.n260 vss_1v2.n243 8.5005
R3007 vss_1v2.n260 vss_1v2.n244 8.5005
R3008 vss_1v2.n260 vss_1v2.n245 8.5005
R3009 vss_1v2.n260 vss_1v2.n246 8.5005
R3010 vss_1v2.n260 vss_1v2.n247 8.5005
R3011 vss_1v2.n260 vss_1v2.n248 8.5005
R3012 vss_1v2.n260 vss_1v2.n249 8.5005
R3013 vss_1v2.n260 vss_1v2.n250 8.5005
R3014 vss_1v2.n260 vss_1v2.n251 8.5005
R3015 vss_1v2.n260 vss_1v2.n252 8.5005
R3016 vss_1v2.n260 vss_1v2.n253 8.5005
R3017 vss_1v2.n260 vss_1v2.n254 8.5005
R3018 vss_1v2.n260 vss_1v2.n255 8.5005
R3019 vss_1v2.n260 vss_1v2.n256 8.5005
R3020 vss_1v2.n260 vss_1v2.n257 8.5005
R3021 vss_1v2.n260 vss_1v2.n258 8.5005
R3022 vss_1v2.n260 vss_1v2.n259 8.5005
R3023 vss_1v2.n5 vss_1v2.n4 8.50133
R3024 vss_1v2.n1978 vss_1v2.n1965 8.5005
R3025 vss_1v2.n2846 vss_1v2.n1976 8.5005
R3026 vss_1v2.n2840 vss_1v2.n2839 8.5005
R3027 vss_1v2.n3554 vss_1v2.n2850 8.5005
R3028 vss_1v2.n3556 vss_1v2.n3555 8.5005
R3029 vss_1v2.n3535 vss_1v2.n933 8.5005
R3030 vss_1v2.n3543 vss_1v2.n933 8.5005
R3031 vss_1v2.n457 vss_1v2.n267 8.5005
R3032 vss_1v2.n3506 vss_1v2.n457 8.5005
R3033 vss_1v2.n3325 vss_1v2.n462 8.5005
R3034 vss_1v2.n2673 vss_1v2.n2663 8.5005
R3035 vss_1v2.n2661 vss_1v2.n3587 8.5005
R3036 vss_1v2.n462 vss_1v2.n267 8.5005
R3037 vss_1v2.n3506 vss_1v2.n462 8.5005
R3038 vss_1v2.n303 vss_1v2.n267 8.5005
R3039 vss_1v2.n3506 vss_1v2.n303 8.5005
R3040 vss_1v2.n3343 vss_1v2.n309 8.5005
R3041 vss_1v2.n3342 vss_1v2.n3341 8.5005
R3042 vss_1v2.n3339 vss_1v2.n307 8.5005
R3043 vss_1v2.n3338 vss_1v2.n3337 8.5005
R3044 vss_1v2.n3337 vss_1v2.n3336 8.5005
R3045 vss_1v2.n3334 vss_1v2.n305 8.5005
R3046 vss_1v2.n3333 vss_1v2.n3332 8.5005
R3047 vss_1v2.n308 vss_1v2.n267 8.5005
R3048 vss_1v2.n3506 vss_1v2.n308 8.5005
R3049 vss_1v2.n2980 vss_1v2.n308 8.5005
R3050 vss_1v2.n3147 vss_1v2.n3146 8.5005
R3051 vss_1v2.n3152 vss_1v2.n3151 8.5005
R3052 vss_1v2.n3154 vss_1v2.n3153 8.5005
R3053 vss_1v2.n3155 vss_1v2.n3154 8.5005
R3054 vss_1v2.n3158 vss_1v2.n3157 8.5005
R3055 vss_1v2.n3160 vss_1v2.n3159 8.5005
R3056 vss_1v2.n3162 vss_1v2.n3161 8.5005
R3057 vss_1v2.n3487 vss_1v2.n267 8.5005
R3058 vss_1v2.n3506 vss_1v2.n2867 8.5005
R3059 vss_1v2.n2883 vss_1v2.n3503 8.5005
R3060 vss_1v2.n3502 vss_1v2.n3501 8.5005
R3061 vss_1v2.n3499 vss_1v2.n3498 8.5005
R3062 vss_1v2.n3497 vss_1v2.n3496 8.5005
R3063 vss_1v2.n3496 vss_1v2.n3495 8.5005
R3064 vss_1v2.n3490 vss_1v2.n2867 8.5005
R3065 vss_1v2.n3505 vss_1v2.n267 8.5005
R3066 vss_1v2.n3506 vss_1v2.n3505 8.5005
R3067 vss_1v2.n3505 vss_1v2.n2878 8.5005
R3068 vss_1v2.n3563 vss_1v2.n3562 8.5005
R3069 vss_1v2.n2681 vss_1v2.n2678 8.5005
R3070 vss_1v2.n3583 vss_1v2.n3582 8.5005
R3071 vss_1v2.n3583 vss_1v2.n2679 8.5005
R3072 vss_1v2.n3574 vss_1v2.n3573 8.5005
R3073 vss_1v2.n3572 vss_1v2.n3571 8.5005
R3074 vss_1v2.n3066 vss_1v2.n2691 8.5005
R3075 vss_1v2.n4030 vss_1v2.n267 8.5005
R3076 vss_1v2.n468 vss_1v2.n1968 2.83239
R3077 vss_1v2.n407 vss_1v2.n1968 8.5005
R3078 vss_1v2.n348 vss_1v2.n1968 8.5005
R3079 vss_1v2.n347 vss_1v2.n1968 8.5005
R3080 vss_1v2.n346 vss_1v2.n1968 8.5005
R3081 vss_1v2.n345 vss_1v2.n1968 8.5005
R3082 vss_1v2.n344 vss_1v2.n1968 8.5005
R3083 vss_1v2.n343 vss_1v2.n1968 8.5005
R3084 vss_1v2.n342 vss_1v2.n1968 8.5005
R3085 vss_1v2.n341 vss_1v2.n1968 8.5005
R3086 vss_1v2.n340 vss_1v2.n1968 8.5005
R3087 vss_1v2.n339 vss_1v2.n1968 8.5005
R3088 vss_1v2.n338 vss_1v2.n1968 8.5005
R3089 vss_1v2.n337 vss_1v2.n1968 8.5005
R3090 vss_1v2.n336 vss_1v2.n1968 8.5005
R3091 vss_1v2.n335 vss_1v2.n1968 8.5005
R3092 vss_1v2.n334 vss_1v2.n1968 8.5005
R3093 vss_1v2.n333 vss_1v2.n1968 8.5005
R3094 vss_1v2.n332 vss_1v2.n1968 8.5005
R3095 vss_1v2.n331 vss_1v2.n1968 8.5005
R3096 vss_1v2.n330 vss_1v2.n1968 8.5005
R3097 vss_1v2.n329 vss_1v2.n1968 8.5005
R3098 vss_1v2.n328 vss_1v2.n1968 8.5005
R3099 vss_1v2.n327 vss_1v2.n1968 8.5005
R3100 vss_1v2.n326 vss_1v2.n1968 8.5005
R3101 vss_1v2.n325 vss_1v2.n1968 8.5005
R3102 vss_1v2.n324 vss_1v2.n1968 8.5005
R3103 vss_1v2.n323 vss_1v2.n1968 8.5005
R3104 vss_1v2.n322 vss_1v2.n1968 8.5005
R3105 vss_1v2.n321 vss_1v2.n1968 8.5005
R3106 vss_1v2.n320 vss_1v2.n1968 8.5005
R3107 vss_1v2.n319 vss_1v2.n1968 8.5005
R3108 vss_1v2.n318 vss_1v2.n1968 8.5005
R3109 vss_1v2.n317 vss_1v2.n1968 8.5005
R3110 vss_1v2.n316 vss_1v2.n1968 8.5005
R3111 vss_1v2.n315 vss_1v2.n1968 8.5005
R3112 vss_1v2.n314 vss_1v2.n1968 8.5005
R3113 vss_1v2.n313 vss_1v2.n1968 8.5005
R3114 vss_1v2.n312 vss_1v2.n1968 8.5005
R3115 vss_1v2.n311 vss_1v2.n1968 8.5005
R3116 vss_1v2.n302 vss_1v2.n1968 8.5005
R3117 vss_1v2.n301 vss_1v2.n1968 8.5005
R3118 vss_1v2.n300 vss_1v2.n1968 8.5005
R3119 vss_1v2.n299 vss_1v2.n1968 8.5005
R3120 vss_1v2.n298 vss_1v2.n1968 8.5005
R3121 vss_1v2.n297 vss_1v2.n1968 8.5005
R3122 vss_1v2.n296 vss_1v2.n1968 8.5005
R3123 vss_1v2.n295 vss_1v2.n1968 8.5005
R3124 vss_1v2.n294 vss_1v2.n1968 8.5005
R3125 vss_1v2.n293 vss_1v2.n1968 8.5005
R3126 vss_1v2.n292 vss_1v2.n1968 8.5005
R3127 vss_1v2.n291 vss_1v2.n1968 8.5005
R3128 vss_1v2.n290 vss_1v2.n1968 8.5005
R3129 vss_1v2.n289 vss_1v2.n1968 8.5005
R3130 vss_1v2.n288 vss_1v2.n1968 8.5005
R3131 vss_1v2.n287 vss_1v2.n1968 8.5005
R3132 vss_1v2.n286 vss_1v2.n1968 8.5005
R3133 vss_1v2.n285 vss_1v2.n1968 8.5005
R3134 vss_1v2.n284 vss_1v2.n1968 8.5005
R3135 vss_1v2.n283 vss_1v2.n1968 8.5005
R3136 vss_1v2.n282 vss_1v2.n1968 8.5005
R3137 vss_1v2.n281 vss_1v2.n1968 8.5005
R3138 vss_1v2.n280 vss_1v2.n1968 8.5005
R3139 vss_1v2.n279 vss_1v2.n1968 8.5005
R3140 vss_1v2.n278 vss_1v2.n1968 8.5005
R3141 vss_1v2.n277 vss_1v2.n1968 8.5005
R3142 vss_1v2.n276 vss_1v2.n1968 8.5005
R3143 vss_1v2.n275 vss_1v2.n1968 8.5005
R3144 vss_1v2.n274 vss_1v2.n1968 8.5005
R3145 vss_1v2.n273 vss_1v2.n1968 8.5005
R3146 vss_1v2.n272 vss_1v2.n1968 8.5005
R3147 vss_1v2.n271 vss_1v2.n1968 8.5005
R3148 vss_1v2.n270 vss_1v2.n1968 8.5005
R3149 vss_1v2.n269 vss_1v2.n1968 8.5005
R3150 vss_1v2.n268 vss_1v2.n1968 8.5005
R3151 vss_1v2.n310 vss_1v2.n1968 8.5005
R3152 vss_1v2.n3838 vss_1v2.n2500 8.5005
R3153 vss_1v2.n3810 vss_1v2.n2525 8.5005
R3154 vss_1v2.n2957 vss_1v2.n457 8.5005
R3155 vss_1v2.n3360 vss_1v2.n3359 8.5005
R3156 vss_1v2.n3364 vss_1v2.n3363 8.5005
R3157 vss_1v2.n3368 vss_1v2.n3355 8.5005
R3158 vss_1v2.n3371 vss_1v2.n3370 8.5005
R3159 vss_1v2.n369 vss_1v2.n462 4.24988
R3160 vss_1v2.n367 vss_1v2.n369 0.00324545
R3161 vss_1v2.n462 vss_1v2.n2525 8.5005
R3162 vss_1v2.n464 vss_1v2.n462 5.66682
R3163 vss_1v2.n2957 vss_1v2.n462 8.5005
R3164 vss_1v2.n3484 vss_1v2.n470 8.5005
R3165 vss_1v2.n462 vss_1v2.n349 8.5005
R3166 vss_1v2.n375 vss_1v2.n470 8.5005
R3167 vss_1v2.n375 vss_1v2.n3373 8.5005
R3168 vss_1v2.n438 vss_1v2.n437 0.00302096
R3169 vss_1v2.n438 vss_1v2.n3375 4.24999
R3170 vss_1v2.n3378 vss_1v2.n3377 8.5005
R3171 vss_1v2.n3381 vss_1v2.n3380 8.5005
R3172 vss_1v2.n3382 vss_1v2.n3381 8.5005
R3173 vss_1v2.n3385 vss_1v2.n3384 8.5005
R3174 vss_1v2.n3387 vss_1v2.n308 8.5005
R3175 vss_1v2.n3484 vss_1v2.n465 8.5005
R3176 vss_1v2.n308 vss_1v2.n349 8.5005
R3177 vss_1v2.n3389 vss_1v2.n308 8.5005
R3178 vss_1v2.n3390 vss_1v2.n2959 8.5005
R3179 vss_1v2.n3392 vss_1v2.n3391 8.5005
R3180 vss_1v2.n3392 vss_1v2.n2960 8.5005
R3181 vss_1v2.n2968 vss_1v2.n2967 8.5005
R3182 vss_1v2.n2971 vss_1v2.n2970 8.5005
R3183 vss_1v2.n2970 vss_1v2.n2965 8.5005
R3184 vss_1v2.n2963 vss_1v2.n2962 8.5005
R3185 vss_1v2.n3487 vss_1v2.n2904 8.5005
R3186 vss_1v2.n3485 vss_1v2.n3484 8.5005
R3187 vss_1v2.n3487 vss_1v2.n349 8.5005
R3188 vss_1v2.n3487 vss_1v2.n373 8.5005
R3189 vss_1v2.n373 vss_1v2.n3427 8.5005
R3190 vss_1v2.n439 vss_1v2.n3428 4.24999
R3191 vss_1v2.n3430 vss_1v2.n3394 8.5005
R3192 vss_1v2.n3433 vss_1v2.n3432 8.5005
R3193 vss_1v2.n3433 vss_1v2.n3399 8.5005
R3194 vss_1v2.n3396 vss_1v2.n3395 8.5005
R3195 vss_1v2.n3505 vss_1v2.n2877 8.5005
R3196 vss_1v2.n3484 vss_1v2.n2929 8.5005
R3197 vss_1v2.n3505 vss_1v2.n349 8.5005
R3198 vss_1v2.n3505 vss_1v2.n377 8.5005
R3199 vss_1v2.n377 vss_1v2.n452 8.5005
R3200 vss_1v2.n3453 vss_1v2.n440 4.24993
R3201 vss_1v2.n3443 vss_1v2.n3442 8.5005
R3202 vss_1v2.n3446 vss_1v2.n3445 8.5005
R3203 vss_1v2.n3440 vss_1v2.n3439 8.5005
R3204 vss_1v2.n3437 vss_1v2.n3436 8.5005
R3205 vss_1v2.n4030 vss_1v2.n1970 8.5005
R3206 vss_1v2.n3484 vss_1v2.n2930 8.5005
R3207 vss_1v2.n4030 vss_1v2.n349 8.5005
R3208 vss_1v2.n3463 vss_1v2.n3462 8.5005
R3209 vss_1v2.n3464 vss_1v2.n3463 8.5005
R3210 vss_1v2.n3468 vss_1v2.n3467 8.5005
R3211 vss_1v2.n3472 vss_1v2.n3471 8.5005
R3212 vss_1v2.n3473 vss_1v2.n3472 8.5005
R3213 vss_1v2.n3476 vss_1v2.n3475 8.5005
R3214 vss_1v2.n3480 vss_1v2.n3479 8.5005
R3215 vss_1v2.n2945 vss_1v2.n1968 8.5005
R3216 vss_1v2.n4030 vss_1v2.n348 8.5005
R3217 vss_1v2.n4030 vss_1v2.n347 8.5005
R3218 vss_1v2.n4030 vss_1v2.n346 8.5005
R3219 vss_1v2.n4030 vss_1v2.n345 8.5005
R3220 vss_1v2.n4030 vss_1v2.n344 8.5005
R3221 vss_1v2.n4030 vss_1v2.n343 8.5005
R3222 vss_1v2.n4030 vss_1v2.n342 8.5005
R3223 vss_1v2.n4030 vss_1v2.n341 8.5005
R3224 vss_1v2.n4030 vss_1v2.n340 8.5005
R3225 vss_1v2.n4030 vss_1v2.n339 8.5005
R3226 vss_1v2.n4030 vss_1v2.n338 8.5005
R3227 vss_1v2.n4030 vss_1v2.n337 8.5005
R3228 vss_1v2.n4030 vss_1v2.n336 8.5005
R3229 vss_1v2.n4030 vss_1v2.n335 8.5005
R3230 vss_1v2.n4030 vss_1v2.n334 8.5005
R3231 vss_1v2.n4030 vss_1v2.n333 8.5005
R3232 vss_1v2.n4030 vss_1v2.n332 8.5005
R3233 vss_1v2.n4030 vss_1v2.n331 8.5005
R3234 vss_1v2.n4030 vss_1v2.n330 8.5005
R3235 vss_1v2.n4030 vss_1v2.n329 8.5005
R3236 vss_1v2.n4030 vss_1v2.n328 8.5005
R3237 vss_1v2.n4030 vss_1v2.n327 8.5005
R3238 vss_1v2.n4030 vss_1v2.n326 8.5005
R3239 vss_1v2.n4030 vss_1v2.n325 8.5005
R3240 vss_1v2.n4030 vss_1v2.n324 8.5005
R3241 vss_1v2.n4030 vss_1v2.n323 8.5005
R3242 vss_1v2.n4030 vss_1v2.n322 8.5005
R3243 vss_1v2.n4030 vss_1v2.n321 8.5005
R3244 vss_1v2.n4030 vss_1v2.n320 8.5005
R3245 vss_1v2.n4030 vss_1v2.n319 8.5005
R3246 vss_1v2.n4030 vss_1v2.n318 8.5005
R3247 vss_1v2.n4030 vss_1v2.n317 8.5005
R3248 vss_1v2.n4030 vss_1v2.n316 8.5005
R3249 vss_1v2.n4030 vss_1v2.n315 8.5005
R3250 vss_1v2.n4030 vss_1v2.n314 8.5005
R3251 vss_1v2.n4030 vss_1v2.n313 8.5005
R3252 vss_1v2.n4030 vss_1v2.n312 8.5005
R3253 vss_1v2.n4030 vss_1v2.n311 8.5005
R3254 vss_1v2.n4030 vss_1v2.n302 8.5005
R3255 vss_1v2.n4030 vss_1v2.n301 8.5005
R3256 vss_1v2.n4030 vss_1v2.n300 8.5005
R3257 vss_1v2.n4030 vss_1v2.n299 8.5005
R3258 vss_1v2.n4030 vss_1v2.n298 8.5005
R3259 vss_1v2.n4030 vss_1v2.n297 8.5005
R3260 vss_1v2.n4030 vss_1v2.n296 8.5005
R3261 vss_1v2.n4030 vss_1v2.n295 8.5005
R3262 vss_1v2.n4030 vss_1v2.n294 8.5005
R3263 vss_1v2.n4030 vss_1v2.n293 8.5005
R3264 vss_1v2.n4030 vss_1v2.n292 8.5005
R3265 vss_1v2.n4030 vss_1v2.n291 8.5005
R3266 vss_1v2.n4030 vss_1v2.n290 8.5005
R3267 vss_1v2.n4030 vss_1v2.n289 8.5005
R3268 vss_1v2.n4030 vss_1v2.n288 8.5005
R3269 vss_1v2.n4030 vss_1v2.n287 8.5005
R3270 vss_1v2.n4030 vss_1v2.n286 8.5005
R3271 vss_1v2.n4030 vss_1v2.n285 8.5005
R3272 vss_1v2.n4030 vss_1v2.n284 8.5005
R3273 vss_1v2.n4030 vss_1v2.n283 8.5005
R3274 vss_1v2.n4030 vss_1v2.n282 8.5005
R3275 vss_1v2.n4030 vss_1v2.n281 8.5005
R3276 vss_1v2.n4030 vss_1v2.n280 8.5005
R3277 vss_1v2.n4030 vss_1v2.n279 8.5005
R3278 vss_1v2.n4030 vss_1v2.n278 8.5005
R3279 vss_1v2.n4030 vss_1v2.n277 8.5005
R3280 vss_1v2.n4030 vss_1v2.n276 8.5005
R3281 vss_1v2.n4030 vss_1v2.n275 8.5005
R3282 vss_1v2.n4030 vss_1v2.n274 8.5005
R3283 vss_1v2.n4030 vss_1v2.n273 8.5005
R3284 vss_1v2.n4030 vss_1v2.n272 8.5005
R3285 vss_1v2.n4030 vss_1v2.n271 8.5005
R3286 vss_1v2.n4030 vss_1v2.n270 8.5005
R3287 vss_1v2.n4030 vss_1v2.n269 8.5005
R3288 vss_1v2.n4030 vss_1v2.n268 8.5005
R3289 vss_1v2.n4030 vss_1v2.n310 8.5005
R3290 vss_1v2.n3505 vss_1v2.n348 8.5005
R3291 vss_1v2.n3505 vss_1v2.n347 8.5005
R3292 vss_1v2.n3505 vss_1v2.n346 8.5005
R3293 vss_1v2.n3505 vss_1v2.n345 8.5005
R3294 vss_1v2.n3505 vss_1v2.n344 8.5005
R3295 vss_1v2.n3505 vss_1v2.n343 8.5005
R3296 vss_1v2.n3505 vss_1v2.n342 8.5005
R3297 vss_1v2.n3505 vss_1v2.n341 8.5005
R3298 vss_1v2.n3505 vss_1v2.n340 8.5005
R3299 vss_1v2.n3505 vss_1v2.n339 8.5005
R3300 vss_1v2.n3505 vss_1v2.n338 8.5005
R3301 vss_1v2.n3505 vss_1v2.n337 8.5005
R3302 vss_1v2.n3505 vss_1v2.n336 8.5005
R3303 vss_1v2.n3505 vss_1v2.n335 8.5005
R3304 vss_1v2.n3505 vss_1v2.n334 8.5005
R3305 vss_1v2.n3505 vss_1v2.n333 8.5005
R3306 vss_1v2.n3505 vss_1v2.n332 8.5005
R3307 vss_1v2.n3505 vss_1v2.n331 8.5005
R3308 vss_1v2.n3505 vss_1v2.n330 8.5005
R3309 vss_1v2.n3505 vss_1v2.n329 8.5005
R3310 vss_1v2.n3505 vss_1v2.n328 8.5005
R3311 vss_1v2.n3505 vss_1v2.n327 8.5005
R3312 vss_1v2.n3505 vss_1v2.n326 8.5005
R3313 vss_1v2.n3505 vss_1v2.n325 8.5005
R3314 vss_1v2.n3505 vss_1v2.n324 8.5005
R3315 vss_1v2.n3505 vss_1v2.n323 8.5005
R3316 vss_1v2.n3505 vss_1v2.n322 8.5005
R3317 vss_1v2.n3505 vss_1v2.n321 8.5005
R3318 vss_1v2.n3505 vss_1v2.n320 8.5005
R3319 vss_1v2.n3505 vss_1v2.n319 8.5005
R3320 vss_1v2.n3505 vss_1v2.n318 8.5005
R3321 vss_1v2.n3505 vss_1v2.n317 8.5005
R3322 vss_1v2.n3505 vss_1v2.n316 8.5005
R3323 vss_1v2.n3505 vss_1v2.n315 8.5005
R3324 vss_1v2.n3505 vss_1v2.n314 8.5005
R3325 vss_1v2.n3505 vss_1v2.n313 8.5005
R3326 vss_1v2.n3505 vss_1v2.n312 8.5005
R3327 vss_1v2.n3505 vss_1v2.n311 8.5005
R3328 vss_1v2.n3505 vss_1v2.n302 8.5005
R3329 vss_1v2.n3505 vss_1v2.n301 8.5005
R3330 vss_1v2.n3505 vss_1v2.n300 8.5005
R3331 vss_1v2.n3505 vss_1v2.n299 8.5005
R3332 vss_1v2.n3505 vss_1v2.n298 8.5005
R3333 vss_1v2.n3505 vss_1v2.n297 8.5005
R3334 vss_1v2.n3505 vss_1v2.n296 8.5005
R3335 vss_1v2.n3505 vss_1v2.n295 8.5005
R3336 vss_1v2.n3505 vss_1v2.n294 8.5005
R3337 vss_1v2.n3505 vss_1v2.n293 8.5005
R3338 vss_1v2.n3505 vss_1v2.n292 8.5005
R3339 vss_1v2.n3505 vss_1v2.n291 8.5005
R3340 vss_1v2.n3505 vss_1v2.n290 8.5005
R3341 vss_1v2.n3505 vss_1v2.n289 8.5005
R3342 vss_1v2.n3505 vss_1v2.n288 8.5005
R3343 vss_1v2.n3505 vss_1v2.n287 8.5005
R3344 vss_1v2.n3505 vss_1v2.n286 8.5005
R3345 vss_1v2.n3505 vss_1v2.n285 8.5005
R3346 vss_1v2.n3505 vss_1v2.n284 8.5005
R3347 vss_1v2.n3505 vss_1v2.n283 8.5005
R3348 vss_1v2.n3505 vss_1v2.n282 8.5005
R3349 vss_1v2.n3505 vss_1v2.n281 8.5005
R3350 vss_1v2.n3505 vss_1v2.n280 8.5005
R3351 vss_1v2.n3505 vss_1v2.n279 8.5005
R3352 vss_1v2.n3505 vss_1v2.n278 8.5005
R3353 vss_1v2.n3505 vss_1v2.n277 8.5005
R3354 vss_1v2.n3505 vss_1v2.n276 8.5005
R3355 vss_1v2.n3505 vss_1v2.n275 8.5005
R3356 vss_1v2.n3505 vss_1v2.n274 8.5005
R3357 vss_1v2.n3505 vss_1v2.n273 8.5005
R3358 vss_1v2.n3505 vss_1v2.n272 8.5005
R3359 vss_1v2.n3505 vss_1v2.n271 8.5005
R3360 vss_1v2.n3505 vss_1v2.n270 8.5005
R3361 vss_1v2.n3505 vss_1v2.n269 8.5005
R3362 vss_1v2.n3505 vss_1v2.n268 8.5005
R3363 vss_1v2.n3505 vss_1v2.n310 8.5005
R3364 vss_1v2.n3487 vss_1v2.n348 8.5005
R3365 vss_1v2.n3487 vss_1v2.n347 8.5005
R3366 vss_1v2.n3487 vss_1v2.n346 8.5005
R3367 vss_1v2.n3487 vss_1v2.n345 8.5005
R3368 vss_1v2.n3487 vss_1v2.n344 8.5005
R3369 vss_1v2.n3487 vss_1v2.n343 8.5005
R3370 vss_1v2.n3487 vss_1v2.n342 8.5005
R3371 vss_1v2.n3487 vss_1v2.n341 8.5005
R3372 vss_1v2.n3487 vss_1v2.n340 8.5005
R3373 vss_1v2.n3487 vss_1v2.n339 8.5005
R3374 vss_1v2.n3487 vss_1v2.n338 8.5005
R3375 vss_1v2.n3487 vss_1v2.n337 8.5005
R3376 vss_1v2.n3487 vss_1v2.n336 8.5005
R3377 vss_1v2.n3487 vss_1v2.n335 8.5005
R3378 vss_1v2.n3487 vss_1v2.n334 8.5005
R3379 vss_1v2.n3487 vss_1v2.n333 8.5005
R3380 vss_1v2.n3487 vss_1v2.n332 8.5005
R3381 vss_1v2.n3487 vss_1v2.n331 8.5005
R3382 vss_1v2.n3487 vss_1v2.n330 8.5005
R3383 vss_1v2.n3487 vss_1v2.n329 8.5005
R3384 vss_1v2.n3487 vss_1v2.n328 8.5005
R3385 vss_1v2.n3487 vss_1v2.n327 8.5005
R3386 vss_1v2.n3487 vss_1v2.n326 8.5005
R3387 vss_1v2.n3487 vss_1v2.n325 8.5005
R3388 vss_1v2.n3487 vss_1v2.n324 8.5005
R3389 vss_1v2.n3487 vss_1v2.n323 8.5005
R3390 vss_1v2.n3487 vss_1v2.n322 8.5005
R3391 vss_1v2.n3487 vss_1v2.n321 8.5005
R3392 vss_1v2.n3487 vss_1v2.n320 8.5005
R3393 vss_1v2.n3487 vss_1v2.n319 8.5005
R3394 vss_1v2.n3487 vss_1v2.n318 8.5005
R3395 vss_1v2.n3487 vss_1v2.n317 8.5005
R3396 vss_1v2.n3487 vss_1v2.n316 8.5005
R3397 vss_1v2.n3487 vss_1v2.n315 8.5005
R3398 vss_1v2.n3487 vss_1v2.n314 8.5005
R3399 vss_1v2.n3487 vss_1v2.n313 8.5005
R3400 vss_1v2.n3487 vss_1v2.n312 8.5005
R3401 vss_1v2.n3487 vss_1v2.n311 8.5005
R3402 vss_1v2.n3487 vss_1v2.n302 8.5005
R3403 vss_1v2.n3487 vss_1v2.n301 8.5005
R3404 vss_1v2.n3487 vss_1v2.n300 8.5005
R3405 vss_1v2.n3487 vss_1v2.n299 8.5005
R3406 vss_1v2.n3487 vss_1v2.n298 8.5005
R3407 vss_1v2.n3487 vss_1v2.n297 8.5005
R3408 vss_1v2.n3487 vss_1v2.n296 8.5005
R3409 vss_1v2.n3487 vss_1v2.n295 8.5005
R3410 vss_1v2.n3487 vss_1v2.n294 8.5005
R3411 vss_1v2.n3487 vss_1v2.n293 8.5005
R3412 vss_1v2.n3487 vss_1v2.n292 8.5005
R3413 vss_1v2.n3487 vss_1v2.n291 8.5005
R3414 vss_1v2.n3487 vss_1v2.n290 8.5005
R3415 vss_1v2.n3487 vss_1v2.n289 8.5005
R3416 vss_1v2.n3487 vss_1v2.n288 8.5005
R3417 vss_1v2.n3487 vss_1v2.n287 8.5005
R3418 vss_1v2.n3487 vss_1v2.n286 8.5005
R3419 vss_1v2.n3487 vss_1v2.n285 8.5005
R3420 vss_1v2.n3487 vss_1v2.n284 8.5005
R3421 vss_1v2.n3487 vss_1v2.n283 8.5005
R3422 vss_1v2.n3487 vss_1v2.n282 8.5005
R3423 vss_1v2.n3487 vss_1v2.n281 8.5005
R3424 vss_1v2.n3487 vss_1v2.n280 8.5005
R3425 vss_1v2.n3487 vss_1v2.n279 8.5005
R3426 vss_1v2.n3487 vss_1v2.n278 8.5005
R3427 vss_1v2.n3487 vss_1v2.n277 8.5005
R3428 vss_1v2.n3487 vss_1v2.n276 8.5005
R3429 vss_1v2.n3487 vss_1v2.n275 8.5005
R3430 vss_1v2.n3487 vss_1v2.n274 8.5005
R3431 vss_1v2.n3487 vss_1v2.n273 8.5005
R3432 vss_1v2.n3487 vss_1v2.n272 8.5005
R3433 vss_1v2.n3487 vss_1v2.n271 8.5005
R3434 vss_1v2.n3487 vss_1v2.n270 8.5005
R3435 vss_1v2.n3487 vss_1v2.n269 8.5005
R3436 vss_1v2.n3487 vss_1v2.n268 8.5005
R3437 vss_1v2.n3487 vss_1v2.n310 8.5005
R3438 vss_1v2.n308 vss_1v2.n348 8.5005
R3439 vss_1v2.n308 vss_1v2.n347 8.5005
R3440 vss_1v2.n308 vss_1v2.n346 8.5005
R3441 vss_1v2.n308 vss_1v2.n345 8.5005
R3442 vss_1v2.n308 vss_1v2.n344 8.5005
R3443 vss_1v2.n308 vss_1v2.n343 8.5005
R3444 vss_1v2.n308 vss_1v2.n342 8.5005
R3445 vss_1v2.n308 vss_1v2.n341 8.5005
R3446 vss_1v2.n308 vss_1v2.n340 8.5005
R3447 vss_1v2.n308 vss_1v2.n339 8.5005
R3448 vss_1v2.n308 vss_1v2.n338 8.5005
R3449 vss_1v2.n308 vss_1v2.n337 8.5005
R3450 vss_1v2.n308 vss_1v2.n336 8.5005
R3451 vss_1v2.n308 vss_1v2.n335 8.5005
R3452 vss_1v2.n308 vss_1v2.n334 8.5005
R3453 vss_1v2.n308 vss_1v2.n333 8.5005
R3454 vss_1v2.n308 vss_1v2.n332 8.5005
R3455 vss_1v2.n308 vss_1v2.n331 8.5005
R3456 vss_1v2.n308 vss_1v2.n330 8.5005
R3457 vss_1v2.n308 vss_1v2.n329 8.5005
R3458 vss_1v2.n308 vss_1v2.n328 8.5005
R3459 vss_1v2.n308 vss_1v2.n327 8.5005
R3460 vss_1v2.n308 vss_1v2.n326 8.5005
R3461 vss_1v2.n308 vss_1v2.n325 8.5005
R3462 vss_1v2.n308 vss_1v2.n324 8.5005
R3463 vss_1v2.n308 vss_1v2.n323 8.5005
R3464 vss_1v2.n308 vss_1v2.n322 8.5005
R3465 vss_1v2.n308 vss_1v2.n321 8.5005
R3466 vss_1v2.n308 vss_1v2.n320 8.5005
R3467 vss_1v2.n308 vss_1v2.n319 8.5005
R3468 vss_1v2.n308 vss_1v2.n318 8.5005
R3469 vss_1v2.n308 vss_1v2.n317 8.5005
R3470 vss_1v2.n308 vss_1v2.n316 8.5005
R3471 vss_1v2.n308 vss_1v2.n315 8.5005
R3472 vss_1v2.n308 vss_1v2.n314 8.5005
R3473 vss_1v2.n308 vss_1v2.n313 8.5005
R3474 vss_1v2.n308 vss_1v2.n312 8.5005
R3475 vss_1v2.n308 vss_1v2.n311 8.5005
R3476 vss_1v2.n308 vss_1v2.n302 8.5005
R3477 vss_1v2.n308 vss_1v2.n301 8.5005
R3478 vss_1v2.n308 vss_1v2.n300 8.5005
R3479 vss_1v2.n308 vss_1v2.n299 8.5005
R3480 vss_1v2.n308 vss_1v2.n298 8.5005
R3481 vss_1v2.n308 vss_1v2.n297 8.5005
R3482 vss_1v2.n308 vss_1v2.n296 8.5005
R3483 vss_1v2.n308 vss_1v2.n295 8.5005
R3484 vss_1v2.n308 vss_1v2.n294 8.5005
R3485 vss_1v2.n308 vss_1v2.n293 8.5005
R3486 vss_1v2.n308 vss_1v2.n292 8.5005
R3487 vss_1v2.n308 vss_1v2.n291 8.5005
R3488 vss_1v2.n308 vss_1v2.n290 8.5005
R3489 vss_1v2.n308 vss_1v2.n289 8.5005
R3490 vss_1v2.n308 vss_1v2.n288 8.5005
R3491 vss_1v2.n308 vss_1v2.n287 8.5005
R3492 vss_1v2.n308 vss_1v2.n286 8.5005
R3493 vss_1v2.n308 vss_1v2.n285 8.5005
R3494 vss_1v2.n308 vss_1v2.n284 8.5005
R3495 vss_1v2.n308 vss_1v2.n283 8.5005
R3496 vss_1v2.n308 vss_1v2.n282 8.5005
R3497 vss_1v2.n308 vss_1v2.n281 8.5005
R3498 vss_1v2.n308 vss_1v2.n280 8.5005
R3499 vss_1v2.n308 vss_1v2.n279 8.5005
R3500 vss_1v2.n308 vss_1v2.n278 8.5005
R3501 vss_1v2.n308 vss_1v2.n277 8.5005
R3502 vss_1v2.n308 vss_1v2.n276 8.5005
R3503 vss_1v2.n308 vss_1v2.n275 8.5005
R3504 vss_1v2.n308 vss_1v2.n274 8.5005
R3505 vss_1v2.n308 vss_1v2.n273 8.5005
R3506 vss_1v2.n308 vss_1v2.n272 8.5005
R3507 vss_1v2.n308 vss_1v2.n271 8.5005
R3508 vss_1v2.n308 vss_1v2.n270 8.5005
R3509 vss_1v2.n308 vss_1v2.n269 8.5005
R3510 vss_1v2.n308 vss_1v2.n268 8.5005
R3511 vss_1v2.n308 vss_1v2.n310 8.5005
R3512 vss_1v2.n3242 vss_1v2.n303 8.5005
R3513 vss_1v2.n3244 vss_1v2.n303 8.5005
R3514 vss_1v2.n3246 vss_1v2.n303 8.5005
R3515 vss_1v2.n3248 vss_1v2.n303 8.5005
R3516 vss_1v2.n3250 vss_1v2.n303 8.5005
R3517 vss_1v2.n3252 vss_1v2.n303 8.5005
R3518 vss_1v2.n3254 vss_1v2.n303 8.5005
R3519 vss_1v2.n3256 vss_1v2.n303 8.5005
R3520 vss_1v2.n3258 vss_1v2.n303 8.5005
R3521 vss_1v2.n3260 vss_1v2.n303 8.5005
R3522 vss_1v2.n3262 vss_1v2.n303 8.5005
R3523 vss_1v2.n3264 vss_1v2.n303 8.5005
R3524 vss_1v2.n3266 vss_1v2.n303 8.5005
R3525 vss_1v2.n3268 vss_1v2.n303 8.5005
R3526 vss_1v2.n3270 vss_1v2.n303 8.5005
R3527 vss_1v2.n3272 vss_1v2.n303 8.5005
R3528 vss_1v2.n3274 vss_1v2.n303 8.5005
R3529 vss_1v2.n3276 vss_1v2.n303 8.5005
R3530 vss_1v2.n3278 vss_1v2.n303 8.5005
R3531 vss_1v2.n3280 vss_1v2.n303 8.5005
R3532 vss_1v2.n3282 vss_1v2.n303 8.5005
R3533 vss_1v2.n3284 vss_1v2.n303 8.5005
R3534 vss_1v2.n3286 vss_1v2.n303 8.5005
R3535 vss_1v2.n3288 vss_1v2.n303 8.5005
R3536 vss_1v2.n3290 vss_1v2.n303 8.5005
R3537 vss_1v2.n3292 vss_1v2.n303 8.5005
R3538 vss_1v2.n3294 vss_1v2.n303 8.5005
R3539 vss_1v2.n3296 vss_1v2.n303 8.5005
R3540 vss_1v2.n3298 vss_1v2.n303 8.5005
R3541 vss_1v2.n3300 vss_1v2.n303 8.5005
R3542 vss_1v2.n3302 vss_1v2.n303 8.5005
R3543 vss_1v2.n3304 vss_1v2.n303 8.5005
R3544 vss_1v2.n3306 vss_1v2.n303 8.5005
R3545 vss_1v2.n3308 vss_1v2.n303 8.5005
R3546 vss_1v2.n3310 vss_1v2.n303 8.5005
R3547 vss_1v2.n3312 vss_1v2.n303 8.5005
R3548 vss_1v2.n462 vss_1v2.n312 8.5005
R3549 vss_1v2.n303 vss_1v2.n302 8.5005
R3550 vss_1v2.n303 vss_1v2.n301 8.5005
R3551 vss_1v2.n303 vss_1v2.n300 8.5005
R3552 vss_1v2.n303 vss_1v2.n299 8.5005
R3553 vss_1v2.n303 vss_1v2.n298 8.5005
R3554 vss_1v2.n303 vss_1v2.n297 8.5005
R3555 vss_1v2.n303 vss_1v2.n296 8.5005
R3556 vss_1v2.n303 vss_1v2.n295 8.5005
R3557 vss_1v2.n303 vss_1v2.n294 8.5005
R3558 vss_1v2.n303 vss_1v2.n293 8.5005
R3559 vss_1v2.n303 vss_1v2.n292 8.5005
R3560 vss_1v2.n303 vss_1v2.n291 8.5005
R3561 vss_1v2.n303 vss_1v2.n290 8.5005
R3562 vss_1v2.n303 vss_1v2.n289 8.5005
R3563 vss_1v2.n303 vss_1v2.n288 8.5005
R3564 vss_1v2.n303 vss_1v2.n287 8.5005
R3565 vss_1v2.n303 vss_1v2.n286 8.5005
R3566 vss_1v2.n303 vss_1v2.n285 8.5005
R3567 vss_1v2.n303 vss_1v2.n284 8.5005
R3568 vss_1v2.n303 vss_1v2.n283 8.5005
R3569 vss_1v2.n303 vss_1v2.n282 8.5005
R3570 vss_1v2.n303 vss_1v2.n281 8.5005
R3571 vss_1v2.n303 vss_1v2.n280 8.5005
R3572 vss_1v2.n303 vss_1v2.n279 8.5005
R3573 vss_1v2.n303 vss_1v2.n278 8.5005
R3574 vss_1v2.n303 vss_1v2.n277 8.5005
R3575 vss_1v2.n303 vss_1v2.n276 8.5005
R3576 vss_1v2.n303 vss_1v2.n275 8.5005
R3577 vss_1v2.n303 vss_1v2.n274 8.5005
R3578 vss_1v2.n303 vss_1v2.n273 8.5005
R3579 vss_1v2.n303 vss_1v2.n272 8.5005
R3580 vss_1v2.n303 vss_1v2.n271 8.5005
R3581 vss_1v2.n303 vss_1v2.n270 8.5005
R3582 vss_1v2.n303 vss_1v2.n269 8.5005
R3583 vss_1v2.n303 vss_1v2.n268 8.5005
R3584 vss_1v2.n462 vss_1v2.n2804 8.5005
R3585 vss_1v2.n462 vss_1v2.n302 8.5005
R3586 vss_1v2.n462 vss_1v2.n301 8.5005
R3587 vss_1v2.n462 vss_1v2.n300 8.5005
R3588 vss_1v2.n462 vss_1v2.n299 8.5005
R3589 vss_1v2.n462 vss_1v2.n298 8.5005
R3590 vss_1v2.n462 vss_1v2.n297 8.5005
R3591 vss_1v2.n462 vss_1v2.n296 8.5005
R3592 vss_1v2.n462 vss_1v2.n295 8.5005
R3593 vss_1v2.n462 vss_1v2.n294 8.5005
R3594 vss_1v2.n462 vss_1v2.n293 8.5005
R3595 vss_1v2.n462 vss_1v2.n292 8.5005
R3596 vss_1v2.n462 vss_1v2.n291 8.5005
R3597 vss_1v2.n462 vss_1v2.n290 8.5005
R3598 vss_1v2.n462 vss_1v2.n289 8.5005
R3599 vss_1v2.n462 vss_1v2.n288 8.5005
R3600 vss_1v2.n462 vss_1v2.n287 8.5005
R3601 vss_1v2.n462 vss_1v2.n286 8.5005
R3602 vss_1v2.n462 vss_1v2.n285 8.5005
R3603 vss_1v2.n462 vss_1v2.n284 8.5005
R3604 vss_1v2.n462 vss_1v2.n283 8.5005
R3605 vss_1v2.n462 vss_1v2.n282 8.5005
R3606 vss_1v2.n462 vss_1v2.n281 8.5005
R3607 vss_1v2.n462 vss_1v2.n280 8.5005
R3608 vss_1v2.n462 vss_1v2.n279 8.5005
R3609 vss_1v2.n462 vss_1v2.n278 8.5005
R3610 vss_1v2.n462 vss_1v2.n277 8.5005
R3611 vss_1v2.n462 vss_1v2.n276 8.5005
R3612 vss_1v2.n462 vss_1v2.n275 8.5005
R3613 vss_1v2.n462 vss_1v2.n274 8.5005
R3614 vss_1v2.n462 vss_1v2.n273 8.5005
R3615 vss_1v2.n462 vss_1v2.n272 8.5005
R3616 vss_1v2.n462 vss_1v2.n271 8.5005
R3617 vss_1v2.n462 vss_1v2.n270 8.5005
R3618 vss_1v2.n462 vss_1v2.n269 8.5005
R3619 vss_1v2.n462 vss_1v2.n268 8.5005
R3620 vss_1v2.n3809 vss_1v2.n457 8.5005
R3621 vss_1v2.n3807 vss_1v2.n457 8.5005
R3622 vss_1v2.n3805 vss_1v2.n457 8.5005
R3623 vss_1v2.n3803 vss_1v2.n457 8.5005
R3624 vss_1v2.n3801 vss_1v2.n457 8.5005
R3625 vss_1v2.n3799 vss_1v2.n457 8.5005
R3626 vss_1v2.n3797 vss_1v2.n457 8.5005
R3627 vss_1v2.n3795 vss_1v2.n457 8.5005
R3628 vss_1v2.n3793 vss_1v2.n457 8.5005
R3629 vss_1v2.n3791 vss_1v2.n457 8.5005
R3630 vss_1v2.n3789 vss_1v2.n457 8.5005
R3631 vss_1v2.n3787 vss_1v2.n457 8.5005
R3632 vss_1v2.n3785 vss_1v2.n457 8.5005
R3633 vss_1v2.n3783 vss_1v2.n457 8.5005
R3634 vss_1v2.n2527 vss_1v2.n457 8.5005
R3635 vss_1v2.n2535 vss_1v2.n457 8.5005
R3636 vss_1v2.n3775 vss_1v2.n457 8.5005
R3637 vss_1v2.n3773 vss_1v2.n457 8.5005
R3638 vss_1v2.n3770 vss_1v2.n457 8.5005
R3639 vss_1v2.n2537 vss_1v2.n457 8.5005
R3640 vss_1v2.n2543 vss_1v2.n457 8.5005
R3641 vss_1v2.n2546 vss_1v2.n457 8.5005
R3642 vss_1v2.n3759 vss_1v2.n457 8.5005
R3643 vss_1v2.n446 vss_1v2.n457 4.24871
R3644 vss_1v2.n2548 vss_1v2.n457 8.5005
R3645 vss_1v2.n2556 vss_1v2.n457 8.5005
R3646 vss_1v2.n2558 vss_1v2.n457 8.5005
R3647 vss_1v2.n3749 vss_1v2.n457 8.5005
R3648 vss_1v2.n3746 vss_1v2.n457 8.5005
R3649 vss_1v2.n450 vss_1v2.n457 4.24871
R3650 vss_1v2.n2567 vss_1v2.n457 8.5005
R3651 vss_1v2.n3737 vss_1v2.n457 8.5005
R3652 vss_1v2.n3735 vss_1v2.n457 8.5005
R3653 vss_1v2.n3732 vss_1v2.n457 8.5005
R3654 vss_1v2.n2574 vss_1v2.n457 8.5005
R3655 vss_1v2.n2576 vss_1v2.n457 8.5005
R3656 vss_1v2.n3721 vss_1v2.n457 8.5005
R3657 vss_1v2.n428 vss_1v2.n457 4.249
R3658 vss_1v2.n2578 vss_1v2.n457 8.5005
R3659 vss_1v2.n2586 vss_1v2.n457 8.5005
R3660 vss_1v2.n2588 vss_1v2.n457 8.5005
R3661 vss_1v2.n3711 vss_1v2.n457 8.5005
R3662 vss_1v2.n3708 vss_1v2.n457 8.5005
R3663 vss_1v2.n3706 vss_1v2.n457 8.5005
R3664 vss_1v2.n2596 vss_1v2.n457 8.5005
R3665 vss_1v2.n2599 vss_1v2.n457 8.5005
R3666 vss_1v2.n3696 vss_1v2.n457 8.5005
R3667 vss_1v2.n3694 vss_1v2.n457 8.5005
R3668 vss_1v2.n3691 vss_1v2.n457 8.5005
R3669 vss_1v2.n2601 vss_1v2.n457 8.5005
R3670 vss_1v2.n2607 vss_1v2.n457 8.5005
R3671 vss_1v2.n2610 vss_1v2.n457 8.5005
R3672 vss_1v2.n3680 vss_1v2.n457 8.5005
R3673 vss_1v2.n421 vss_1v2.n457 4.249
R3674 vss_1v2.n2612 vss_1v2.n457 8.5005
R3675 vss_1v2.n2620 vss_1v2.n457 8.5005
R3676 vss_1v2.n2622 vss_1v2.n457 8.5005
R3677 vss_1v2.n3670 vss_1v2.n457 8.5005
R3678 vss_1v2.n3667 vss_1v2.n457 8.5005
R3679 vss_1v2.n432 vss_1v2.n457 4.249
R3680 vss_1v2.n2630 vss_1v2.n457 8.5005
R3681 vss_1v2.n3658 vss_1v2.n457 8.5005
R3682 vss_1v2.n3656 vss_1v2.n457 8.5005
R3683 vss_1v2.n3653 vss_1v2.n457 8.5005
R3684 vss_1v2.n2632 vss_1v2.n457 8.5005
R3685 vss_1v2.n2639 vss_1v2.n457 8.5005
R3686 vss_1v2.n2642 vss_1v2.n457 8.5005
R3687 vss_1v2.n2804 vss_1v2.n457 8.5005
R3688 vss_1v2.n2800 vss_1v2.n457 8.5005
R3689 vss_1v2.n2797 vss_1v2.n457 8.5005
R3690 vss_1v2.n2794 vss_1v2.n457 8.5005
R3691 vss_1v2.n2791 vss_1v2.n457 8.5005
R3692 vss_1v2.n2788 vss_1v2.n457 8.5005
R3693 vss_1v2.n2785 vss_1v2.n457 8.5005
R3694 vss_1v2.n2782 vss_1v2.n457 8.5005
R3695 vss_1v2.n2779 vss_1v2.n457 8.5005
R3696 vss_1v2.n2776 vss_1v2.n457 8.5005
R3697 vss_1v2.n2773 vss_1v2.n457 8.5005
R3698 vss_1v2.n2770 vss_1v2.n457 8.5005
R3699 vss_1v2.n2767 vss_1v2.n457 8.5005
R3700 vss_1v2.t301 vss_1v2.n457 8.5005
R3701 vss_1v2.n2764 vss_1v2.n457 8.5005
R3702 vss_1v2.n2761 vss_1v2.n457 8.5005
R3703 vss_1v2.n2758 vss_1v2.n457 8.5005
R3704 vss_1v2.n2755 vss_1v2.n457 8.5005
R3705 vss_1v2.n2752 vss_1v2.n457 8.5005
R3706 vss_1v2.n2749 vss_1v2.n457 8.5005
R3707 vss_1v2.n2746 vss_1v2.n457 8.5005
R3708 vss_1v2.n2743 vss_1v2.n457 8.5005
R3709 vss_1v2.n2740 vss_1v2.n457 8.5005
R3710 vss_1v2.n2737 vss_1v2.n457 8.5005
R3711 vss_1v2.n2734 vss_1v2.n457 8.5005
R3712 vss_1v2.n2731 vss_1v2.n457 8.5005
R3713 vss_1v2.n2728 vss_1v2.n457 8.5005
R3714 vss_1v2.n2725 vss_1v2.n457 8.5005
R3715 vss_1v2.n2722 vss_1v2.n457 8.5005
R3716 vss_1v2.n2719 vss_1v2.n457 8.5005
R3717 vss_1v2.n2716 vss_1v2.n457 8.5005
R3718 vss_1v2.n2713 vss_1v2.n457 8.5005
R3719 vss_1v2.n2710 vss_1v2.n457 8.5005
R3720 vss_1v2.n2707 vss_1v2.n457 8.5005
R3721 vss_1v2.n2704 vss_1v2.n457 8.5005
R3722 vss_1v2.n2701 vss_1v2.n457 8.5005
R3723 vss_1v2.n457 vss_1v2.n311 8.5005
R3724 vss_1v2.n457 vss_1v2.n302 8.5005
R3725 vss_1v2.n457 vss_1v2.n301 8.5005
R3726 vss_1v2.n457 vss_1v2.n300 8.5005
R3727 vss_1v2.n457 vss_1v2.n299 8.5005
R3728 vss_1v2.n457 vss_1v2.n298 8.5005
R3729 vss_1v2.n457 vss_1v2.n297 8.5005
R3730 vss_1v2.n457 vss_1v2.n296 8.5005
R3731 vss_1v2.n457 vss_1v2.n295 8.5005
R3732 vss_1v2.n457 vss_1v2.n294 8.5005
R3733 vss_1v2.n457 vss_1v2.n293 8.5005
R3734 vss_1v2.n457 vss_1v2.n292 8.5005
R3735 vss_1v2.n457 vss_1v2.n291 8.5005
R3736 vss_1v2.n457 vss_1v2.n290 8.5005
R3737 vss_1v2.n457 vss_1v2.n289 8.5005
R3738 vss_1v2.n457 vss_1v2.n288 8.5005
R3739 vss_1v2.n457 vss_1v2.n287 8.5005
R3740 vss_1v2.n457 vss_1v2.n286 8.5005
R3741 vss_1v2.n457 vss_1v2.n285 8.5005
R3742 vss_1v2.n457 vss_1v2.n284 8.5005
R3743 vss_1v2.n457 vss_1v2.n283 8.5005
R3744 vss_1v2.n457 vss_1v2.n282 8.5005
R3745 vss_1v2.n457 vss_1v2.n281 8.5005
R3746 vss_1v2.n457 vss_1v2.n280 8.5005
R3747 vss_1v2.n457 vss_1v2.n279 8.5005
R3748 vss_1v2.n457 vss_1v2.n278 8.5005
R3749 vss_1v2.n457 vss_1v2.n277 8.5005
R3750 vss_1v2.n457 vss_1v2.n276 8.5005
R3751 vss_1v2.n457 vss_1v2.n275 8.5005
R3752 vss_1v2.n457 vss_1v2.n274 8.5005
R3753 vss_1v2.n457 vss_1v2.n273 8.5005
R3754 vss_1v2.n457 vss_1v2.n272 8.5005
R3755 vss_1v2.n457 vss_1v2.n271 8.5005
R3756 vss_1v2.n457 vss_1v2.n270 8.5005
R3757 vss_1v2.n457 vss_1v2.n269 8.5005
R3758 vss_1v2.n457 vss_1v2.n268 8.5005
R3759 vss_1v2.n457 vss_1v2.n310 8.5005
R3760 vss_1v2.n3642 vss_1v2.n457 8.5005
R3761 vss_1v2.n4128 vss_1v2.n4121 8.5005
R3762 vss_1v2.n4121 vss_1v2.n1856 8.5005
R3763 vss_1v2.n4123 vss_1v2.n4121 8.5005
R3764 vss_1v2.n4121 vss_1v2.n717 8.5005
R3765 vss_1v2.n4121 vss_1v2.n1855 8.5005
R3766 vss_1v2.n4128 vss_1v2.n4122 8.5005
R3767 vss_1v2.n4122 vss_1v2.n1856 8.5005
R3768 vss_1v2.n4123 vss_1v2.n4122 8.5005
R3769 vss_1v2.n4122 vss_1v2.n717 8.5005
R3770 vss_1v2.n4122 vss_1v2.n1855 8.5005
R3771 vss_1v2.n4128 vss_1v2.n4127 8.5005
R3772 vss_1v2.n4127 vss_1v2.n1856 8.5005
R3773 vss_1v2.n4127 vss_1v2.n4123 8.5005
R3774 vss_1v2.n4127 vss_1v2.n717 8.5005
R3775 vss_1v2.n4127 vss_1v2.n1855 8.5005
R3776 vss_1v2.n208 vss_1v2.n18 4.23357
R3777 vss_1v2.n16 vss_1v2.n1927 8.5005
R3778 vss_1v2.n16 vss_1v2.n1926 8.5005
R3779 vss_1v2.n16 vss_1v2.n1925 8.5005
R3780 vss_1v2.n16 vss_1v2.n1924 8.5005
R3781 vss_1v2.n16 vss_1v2.n1923 8.5005
R3782 vss_1v2.n16 vss_1v2.n1915 8.5005
R3783 vss_1v2.n1920 vss_1v2.n16 8.5005
R3784 vss_1v2.n16 vss_1v2.n1919 8.5005
R3785 vss_1v2.n16 vss_1v2.n1913 8.5005
R3786 vss_1v2.n16 vss_1v2.n1914 8.5005
R3787 vss_1v2.n1857 vss_1v2.n18 8.5005
R3788 vss_1v2.n16 vss_1v2.n208 4.22738
R3789 vss_1v2.n16 vss_1v2.n3109 8.5005
R3790 vss_1v2.n16 vss_1v2.n1936 8.5005
R3791 vss_1v2.n16 vss_1v2.n1935 8.5005
R3792 vss_1v2.n16 vss_1v2.n360 4.24957
R3793 vss_1v2.n16 vss_1v2.n1932 8.5005
R3794 vss_1v2.n1933 vss_1v2.n16 8.5005
R3795 vss_1v2.n16 vss_1v2.n1929 8.5005
R3796 vss_1v2.n16 vss_1v2.n1928 8.5005
R3797 vss_1v2.n16 vss_1v2.n2999 8.5005
R3798 vss_1v2.n16 vss_1v2.n32 6.3583
R3799 vss_1v2.n2 vss_1v2.n356 4.25087
R3800 vss_1v2.n16 vss_1v2.n51 4.25009
R3801 vss_1v2.n16 vss_1v2.n84 4.25009
R3802 vss_1v2.n1939 vss_1v2.n16 8.5005
R3803 vss_1v2.n16 vss_1v2.n45 1.69769
R3804 vss_1v2.n2 vss_1v2.n85 2.12454
R3805 vss_1v2.n2 vss_1v2.n211 8.5005
R3806 vss_1v2.n2 vss_1v2.n1950 8.5005
R3807 vss_1v2.n2 vss_1v2.n1949 8.5005
R3808 vss_1v2.n2 vss_1v2.n1942 8.5005
R3809 vss_1v2.n2 vss_1v2.n1948 8.5005
R3810 vss_1v2.n2 vss_1v2.n1941 8.5005
R3811 vss_1v2.n363 vss_1v2.n2 4.25087
R3812 vss_1v2.n2 vss_1v2.n1946 8.5005
R3813 vss_1v2.n2 vss_1v2.n3055 8.5005
R3814 vss_1v2.n2 vss_1v2.n3056 8.5005
R3815 vss_1v2.t46 vss_1v2.n46 8.5005
R3816 vss_1v2.t46 vss_1v2.n1911 8.5005
R3817 vss_1v2.t46 vss_1v2.n1912 8.5005
R3818 vss_1v2.n2 vss_1v2.n1951 8.5005
R3819 vss_1v2.n72 vss_1v2.n4099 8.5005
R3820 vss_1v2.n18 vss_1v2.n38 2.80983
R3821 vss_1v2.n18 vss_1v2.n207 8.5005
R3822 vss_1v2.n78 vss_1v2.n18 2.81086
R3823 vss_1v2.n18 vss_1v2.n1396 8.5005
R3824 vss_1v2.n4105 vss_1v2.n18 8.5005
R3825 vss_1v2.n85 vss_1v2.n18 4.24902
R3826 vss_1v2.n4130 vss_1v2.n18 4.22709
R3827 vss_1v2.n18 vss_1v2.n205 4.24432
R3828 vss_1v2.n18 vss_1v2.n203 4.24754
R3829 vss_1v2.n18 vss_1v2.n202 4.2272
R3830 vss_1v2.n18 vss_1v2.n201 4.24914
R3831 vss_1v2.n18 vss_1v2.n200 4.22732
R3832 vss_1v2.n18 vss_1v2.n198 4.22743
R3833 vss_1v2.n18 vss_1v2.n197 4.24995
R3834 vss_1v2.n18 vss_1v2.n196 4.22755
R3835 vss_1v2.n18 vss_1v2.n195 4.25035
R3836 vss_1v2.n18 vss_1v2.n194 4.22767
R3837 vss_1v2.n18 vss_1v2.n192 4.22779
R3838 vss_1v2.n18 vss_1v2.n191 4.25055
R3839 vss_1v2.n18 vss_1v2.n190 4.22792
R3840 vss_1v2.n18 vss_1v2.n189 4.25065
R3841 vss_1v2.n18 vss_1v2.n187 4.2507
R3842 vss_1v2.n18 vss_1v2.n186 4.22804
R3843 vss_1v2.n18 vss_1v2.n185 4.25072
R3844 vss_1v2.n18 vss_1v2.n184 4.22817
R3845 vss_1v2.n14 vss_1v2.n183 0.850179
R3846 vss_1v2.n18 vss_1v2.n181 4.22068
R3847 vss_1v2.n18 vss_1v2.n180 4.22829
R3848 vss_1v2.n18 vss_1v2.n179 4.23577
R3849 vss_1v2.n18 vss_1v2.n178 4.22842
R3850 vss_1v2.n18 vss_1v2.n176 4.22855
R3851 vss_1v2.n18 vss_1v2.n175 4.24327
R3852 vss_1v2.n18 vss_1v2.n174 4.22868
R3853 vss_1v2.n18 vss_1v2.n173 4.24702
R3854 vss_1v2.n18 vss_1v2.n170 4.22881
R3855 vss_1v2.n18 vss_1v2.n169 4.24888
R3856 vss_1v2.n18 vss_1v2.n168 4.22895
R3857 vss_1v2.n18 vss_1v2.n167 4.24982
R3858 vss_1v2.n18 vss_1v2.n165 4.25028
R3859 vss_1v2.n18 vss_1v2.n164 4.22908
R3860 vss_1v2.n18 vss_1v2.n163 4.25052
R3861 vss_1v2.n18 vss_1v2.n162 4.22922
R3862 vss_1v2.n18 vss_1v2.n159 4.25063
R3863 vss_1v2.n18 vss_1v2.n158 4.22936
R3864 vss_1v2.n18 vss_1v2.n157 4.25069
R3865 vss_1v2.n18 vss_1v2.n156 4.2295
R3866 vss_1v2.n18 vss_1v2.n155 1.34569
R3867 vss_1v2.n18 vss_1v2.n154 4.22964
R3868 vss_1v2.n18 vss_1v2.n153 4.21616
R3869 vss_1v2.n18 vss_1v2.n152 4.22978
R3870 vss_1v2.n18 vss_1v2.n151 4.23353
R3871 vss_1v2.n18 vss_1v2.n70 4.22992
R3872 vss_1v2.n18 vss_1v2.n53 4.24216
R3873 vss_1v2.n18 vss_1v2.n69 4.23007
R3874 vss_1v2.n18 vss_1v2.n54 4.24646
R3875 vss_1v2.n18 vss_1v2.n55 4.24861
R3876 vss_1v2.n18 vss_1v2.n67 4.23021
R3877 vss_1v2.n18 vss_1v2.n56 4.24968
R3878 vss_1v2.n18 vss_1v2.n57 2.82965
R3879 vss_1v2.n18 vss_1v2.n58 2.79573
R3880 vss_1v2.n18 vss_1v2.n64 2.8159
R3881 vss_1v2.n18 vss_1v2.n59 2.83358
R3882 vss_1v2.n18 vss_1v2.n63 2.81567
R3883 vss_1v2.n18 vss_1v2.n60 2.83062
R3884 vss_1v2.n18 vss_1v2.n62 2.81478
R3885 vss_1v2.n18 vss_1v2.n61 2.82962
R3886 vss_1v2.n18 vss_1v2.n148 2.81187
R3887 vss_1v2.n18 vss_1v2.n147 2.82056
R3888 vss_1v2.n18 vss_1v2.n145 2.80804
R3889 vss_1v2.n18 vss_1v2.n144 2.81242
R3890 vss_1v2.n18 vss_1v2.n143 2.82193
R3891 vss_1v2.n18 vss_1v2.n142 2.81058
R3892 vss_1v2.n18 vss_1v2.n141 2.81877
R3893 vss_1v2.n17 vss_1v2.n140 1.37233
R3894 vss_1v2.n18 vss_1v2.n139 2.79915
R3895 vss_1v2.n18 vss_1v2.n138 2.81665
R3896 vss_1v2.n18 vss_1v2.n137 2.81085
R3897 vss_1v2.n18 vss_1v2.n136 2.8165
R3898 vss_1v2.n18 vss_1v2.n134 2.81597
R3899 vss_1v2.n18 vss_1v2.n133 2.82198
R3900 vss_1v2.n18 vss_1v2.n132 2.81313
R3901 vss_1v2.n18 vss_1v2.n131 2.81943
R3902 vss_1v2.n18 vss_1v2.n130 2.81714
R3903 vss_1v2.n18 vss_1v2.n128 2.81723
R3904 vss_1v2.n18 vss_1v2.n127 2.82946
R3905 vss_1v2.n18 vss_1v2.n126 2.81712
R3906 vss_1v2.n18 vss_1v2.n125 2.83052
R3907 vss_1v2.n18 vss_1v2.n123 2.83039
R3908 vss_1v2.n18 vss_1v2.n122 2.8141
R3909 vss_1v2.n18 vss_1v2.n121 2.82587
R3910 vss_1v2.n18 vss_1v2.n120 2.81763
R3911 vss_1v2.n13 vss_1v2.n119 0.624619
R3912 vss_1v2.n18 vss_1v2.n117 2.83319
R3913 vss_1v2.n18 vss_1v2.n116 2.81772
R3914 vss_1v2.n18 vss_1v2.n115 2.8334
R3915 vss_1v2.n18 vss_1v2.n114 2.81767
R3916 vss_1v2.n18 vss_1v2.n112 2.81757
R3917 vss_1v2.n18 vss_1v2.n111 2.81951
R3918 vss_1v2.n18 vss_1v2.n110 2.81631
R3919 vss_1v2.n18 vss_1v2.n109 2.81657
R3920 vss_1v2.n18 vss_1v2.n107 2.82104
R3921 vss_1v2.n18 vss_1v2.n106 2.81283
R3922 vss_1v2.n18 vss_1v2.n105 2.81476
R3923 vss_1v2.n18 vss_1v2.n104 2.81315
R3924 vss_1v2.n18 vss_1v2.n103 2.81481
R3925 vss_1v2.n18 vss_1v2.n102 2.82241
R3926 vss_1v2.n18 vss_1v2.n101 2.8191
R3927 vss_1v2.n18 vss_1v2.n100 2.81707
R3928 vss_1v2.n18 vss_1v2.n99 2.81674
R3929 vss_1v2.n16 vss_1v2.n98 2.82041
R3930 vss_1v2.n18 vss_1v2.n96 2.82858
R3931 vss_1v2.n18 vss_1v2.n95 2.81741
R3932 vss_1v2.n16 vss_1v2.n94 2.82528
R3933 vss_1v2.n18 vss_1v2.n93 2.81925
R3934 vss_1v2.n18 vss_1v2.n92 2.81836
R3935 vss_1v2.n18 vss_1v2.n90 2.81754
R3936 vss_1v2.n18 vss_1v2.n89 4.2339
R3937 vss_1v2.n18 vss_1v2.n87 2.81843
R3938 vss_1v2.n4130 vss_1v2.n16 8.5005
R3939 vss_1v2.n16 vss_1v2.n205 8.5005
R3940 vss_1v2.n16 vss_1v2.n204 2.04514
R3941 vss_1v2.n16 vss_1v2.n202 8.5005
R3942 vss_1v2.n16 vss_1v2.n201 8.5005
R3943 vss_1v2.n16 vss_1v2.n200 8.5005
R3944 vss_1v2.n16 vss_1v2.n197 8.5005
R3945 vss_1v2.n16 vss_1v2.n196 8.5005
R3946 vss_1v2.n16 vss_1v2.n195 8.5005
R3947 vss_1v2.n16 vss_1v2.n194 8.5005
R3948 vss_1v2.n16 vss_1v2.n193 2.79709
R3949 vss_1v2.n16 vss_1v2.n192 2.09176
R3950 vss_1v2.n16 vss_1v2.n191 8.5005
R3951 vss_1v2.n16 vss_1v2.n190 8.5005
R3952 vss_1v2.n16 vss_1v2.n189 8.5005
R3953 vss_1v2.n16 vss_1v2.n186 8.5005
R3954 vss_1v2.n16 vss_1v2.n185 8.5005
R3955 vss_1v2.n16 vss_1v2.n184 8.5005
R3956 vss_1v2.n16 vss_1v2.n181 8.5005
R3957 vss_1v2.n16 vss_1v2.n180 8.5005
R3958 vss_1v2.n16 vss_1v2.n179 8.5005
R3959 vss_1v2.n16 vss_1v2.n178 8.5005
R3960 vss_1v2.n16 vss_1v2.n175 8.5005
R3961 vss_1v2.n16 vss_1v2.n174 8.5005
R3962 vss_1v2.n16 vss_1v2.n173 8.5005
R3963 vss_1v2.n16 vss_1v2.n170 8.5005
R3964 vss_1v2.n16 vss_1v2.n169 8.5005
R3965 vss_1v2.n16 vss_1v2.n168 8.5005
R3966 vss_1v2.n16 vss_1v2.n167 8.5005
R3967 vss_1v2.n16 vss_1v2.n164 8.5005
R3968 vss_1v2.n16 vss_1v2.n163 8.5005
R3969 vss_1v2.n16 vss_1v2.n162 8.5005
R3970 vss_1v2.n16 vss_1v2.n160 2.10218
R3971 vss_1v2.n16 vss_1v2.n159 8.5005
R3972 vss_1v2.n16 vss_1v2.n158 8.5005
R3973 vss_1v2.n16 vss_1v2.n157 8.5005
R3974 vss_1v2.n16 vss_1v2.n156 8.5005
R3975 vss_1v2.n16 vss_1v2.n154 2.79371
R3976 vss_1v2.n16 vss_1v2.n153 8.5005
R3977 vss_1v2.n16 vss_1v2.n7 0.264579
R3978 vss_1v2.n7 vss_1v2.n2 0.132797
R3979 vss_1v2.t46 vss_1v2.n172 0.898938
R3980 vss_1v2.n16 vss_1v2.n17 0.0751035
R3981 vss_1v2.n16 vss_1v2.n137 8.5005
R3982 vss_1v2.n16 vss_1v2.n136 8.5005
R3983 vss_1v2.n16 vss_1v2.n133 8.5005
R3984 vss_1v2.n16 vss_1v2.n132 8.5005
R3985 vss_1v2.n16 vss_1v2.n131 8.5005
R3986 vss_1v2.n16 vss_1v2.n130 8.5005
R3987 vss_1v2.n16 vss_1v2.n127 8.5005
R3988 vss_1v2.n16 vss_1v2.n126 8.5005
R3989 vss_1v2.n16 vss_1v2.n125 8.5005
R3990 vss_1v2.n16 vss_1v2.n123 4.23014
R3991 vss_1v2.n16 vss_1v2.n122 8.5005
R3992 vss_1v2.n16 vss_1v2.n121 8.5005
R3993 vss_1v2.n16 vss_1v2.n120 8.5005
R3994 vss_1v2.n16 vss_1v2.n118 2.79297
R3995 vss_1v2.n16 vss_1v2.n117 8.5005
R3996 vss_1v2.n16 vss_1v2.n116 8.5005
R3997 vss_1v2.n16 vss_1v2.n115 8.5005
R3998 vss_1v2.n16 vss_1v2.n114 8.5005
R3999 vss_1v2.n16 vss_1v2.n111 8.5005
R4000 vss_1v2.n16 vss_1v2.n110 8.5005
R4001 vss_1v2.n16 vss_1v2.n109 8.5005
R4002 vss_1v2.n2 vss_1v2.n107 2.80492
R4003 vss_1v2.n16 vss_1v2.n106 8.5005
R4004 vss_1v2.n16 vss_1v2.n105 8.5005
R4005 vss_1v2.n16 vss_1v2.n104 8.5005
R4006 vss_1v2.n16 vss_1v2.n103 8.5005
R4007 vss_1v2.n16 vss_1v2.n100 8.5005
R4008 vss_1v2.n16 vss_1v2.n99 8.5005
R4009 vss_1v2.n16 vss_1v2.n95 8.5005
R4010 vss_1v2.n16 vss_1v2.n93 8.5005
R4011 vss_1v2.n16 vss_1v2.n92 8.5005
R4012 vss_1v2.n16 vss_1v2.n88 2.83267
R4013 vss_1v2.n16 vss_1v2.n86 0.794149
R4014 vss_1v2.n4130 vss_1v2.n2 4.24613
R4015 vss_1v2.n2 vss_1v2.n202 2.82739
R4016 vss_1v2.n2 vss_1v2.n196 2.79329
R4017 vss_1v2.n2 vss_1v2.n186 2.82145
R4018 vss_1v2.n2 vss_1v2.n185 2.80856
R4019 vss_1v2.n2 vss_1v2.n184 2.79543
R4020 vss_1v2.n2 vss_1v2.n180 2.83411
R4021 vss_1v2.n2 vss_1v2.n179 2.83411
R4022 vss_1v2.n2 vss_1v2.n178 2.83411
R4023 vss_1v2.n2 vss_1v2.n175 2.83411
R4024 vss_1v2.n2 vss_1v2.n174 2.83411
R4025 vss_1v2.n2 vss_1v2.n173 2.83411
R4026 vss_1v2.n2 vss_1v2.n170 2.82852
R4027 vss_1v2.n2 vss_1v2.n169 2.83132
R4028 vss_1v2.n2 vss_1v2.n168 2.83272
R4029 vss_1v2.n2 vss_1v2.n167 2.83342
R4030 vss_1v2.n2 vss_1v2.n164 2.83395
R4031 vss_1v2.n2 vss_1v2.n163 2.83405
R4032 vss_1v2.n2 vss_1v2.n162 2.8341
R4033 vss_1v2.n2 vss_1v2.n159 2.83417
R4034 vss_1v2.n11 vss_1v2.t46 0.0790124
R4035 vss_1v2.n2 vss_1v2.n11 0.160181
R4036 vss_1v2.n2 vss_1v2.n153 4.25075
R4037 vss_1v2.n7 vss_1v2.n152 2.74658
R4038 vss_1v2.n2 vss_1v2.n151 2.02433
R4039 vss_1v2.n2 vss_1v2.n70 2.12232
R4040 vss_1v2.n2 vss_1v2.n53 2.1211
R4041 vss_1v2.n2 vss_1v2.n69 2.11951
R4042 vss_1v2.n2 vss_1v2.n54 2.11738
R4043 vss_1v2.n2 vss_1v2.n55 2.09216
R4044 vss_1v2.n2 vss_1v2.n67 2.11452
R4045 vss_1v2.n2 vss_1v2.n56 2.11067
R4046 vss_1v2.n2 vss_1v2.n66 2.8341
R4047 vss_1v2.n2 vss_1v2.n58 2.83407
R4048 vss_1v2.n2 vss_1v2.n64 2.83402
R4049 vss_1v2.n2 vss_1v2.n59 2.83393
R4050 vss_1v2.n2 vss_1v2.n63 2.83375
R4051 vss_1v2.n2 vss_1v2.n62 2.83339
R4052 vss_1v2.n2 vss_1v2.n61 2.83266
R4053 vss_1v2.n2 vss_1v2.n148 2.83121
R4054 vss_1v2.n2 vss_1v2.n147 2.82829
R4055 vss_1v2.n2 vss_1v2.n145 2.83411
R4056 vss_1v2.n2 vss_1v2.n144 2.83411
R4057 vss_1v2.n16 vss_1v2.n143 2.83411
R4058 vss_1v2.n2 vss_1v2.n142 2.80688
R4059 vss_1v2.n2 vss_1v2.n141 2.79286
R4060 vss_1v2.n2 vss_1v2.n138 2.7713
R4061 vss_1v2.n16 vss_1v2.n129 2.82446
R4062 vss_1v2.n13 vss_1v2.t46 0.566112
R4063 vss_1v2.n2 vss_1v2.n6 0.453527
R4064 vss_1v2.n205 vss_1v2.t46 0.382111
R4065 vss_1v2.n204 vss_1v2.n8 1.06601
R4066 vss_1v2.n203 vss_1v2.t46 1.17808
R4067 vss_1v2.n202 vss_1v2.t46 2.83184
R4068 vss_1v2.n201 vss_1v2.t46 1.3882
R4069 vss_1v2.n200 vss_1v2.t46 1.40753
R4070 vss_1v2.n199 vss_1v2.t46 1.38517
R4071 vss_1v2.n198 vss_1v2.t46 1.20362
R4072 vss_1v2.n197 vss_1v2.t46 1.38916
R4073 vss_1v2.n196 vss_1v2.t46 2.82434
R4074 vss_1v2.n195 vss_1v2.t46 1.39618
R4075 vss_1v2.n194 vss_1v2.t46 1.38258
R4076 vss_1v2.n193 vss_1v2.t46 2.09705
R4077 vss_1v2.n192 vss_1v2.t46 2.82752
R4078 vss_1v2.n191 vss_1v2.t46 1.39932
R4079 vss_1v2.n190 vss_1v2.t46 1.39864
R4080 vss_1v2.n189 vss_1v2.t46 1.3588
R4081 vss_1v2.n187 vss_1v2.t46 1.20097
R4082 vss_1v2.n186 vss_1v2.t46 2.81915
R4083 vss_1v2.n185 vss_1v2.t46 2.80795
R4084 vss_1v2.n184 vss_1v2.t46 2.81797
R4085 vss_1v2.n182 vss_1v2.n2 1.2019
R4086 vss_1v2.n181 vss_1v2.t46 1.38356
R4087 vss_1v2.n180 vss_1v2.t46 2.80375
R4088 vss_1v2.n179 vss_1v2.t46 2.8277
R4089 vss_1v2.n178 vss_1v2.t46 2.81824
R4090 vss_1v2.n176 vss_1v2.t46 1.17429
R4091 vss_1v2.n175 vss_1v2.t46 2.81234
R4092 vss_1v2.n174 vss_1v2.t46 2.82829
R4093 vss_1v2.n173 vss_1v2.t46 2.8094
R4094 vss_1v2.n171 vss_1v2.n2 1.19752
R4095 vss_1v2.n170 vss_1v2.t46 2.82899
R4096 vss_1v2.n169 vss_1v2.t46 2.82508
R4097 vss_1v2.n168 vss_1v2.t46 2.81503
R4098 vss_1v2.n167 vss_1v2.t46 2.82932
R4099 vss_1v2.n165 vss_1v2.t46 1.20883
R4100 vss_1v2.n164 vss_1v2.t46 2.81962
R4101 vss_1v2.n163 vss_1v2.t46 2.83204
R4102 vss_1v2.n162 vss_1v2.t46 2.81938
R4103 vss_1v2.n160 vss_1v2.t46 2.81544
R4104 vss_1v2.n159 vss_1v2.t46 2.8321
R4105 vss_1v2.n158 vss_1v2.t46 1.27586
R4106 vss_1v2.n157 vss_1v2.t46 1.32829
R4107 vss_1v2.n156 vss_1v2.n11 1.34654
R4108 vss_1v2.n155 vss_1v2.t46 2.83109
R4109 vss_1v2.n154 vss_1v2.t46 2.07987
R4110 vss_1v2.n153 vss_1v2.t46 2.12062
R4111 vss_1v2.n152 vss_1v2.t46 2.12785
R4112 vss_1v2.n151 vss_1v2.t46 2.82835
R4113 vss_1v2.n150 vss_1v2.t46 1.69481
R4114 vss_1v2.n149 vss_1v2.t46 1.1998
R4115 vss_1v2.n70 vss_1v2.t46 2.82472
R4116 vss_1v2.n53 vss_1v2.t46 2.82286
R4117 vss_1v2.n69 vss_1v2.t46 2.8174
R4118 vss_1v2.n54 vss_1v2.t46 2.79373
R4119 vss_1v2.n68 vss_1v2.t46 1.19054
R4120 vss_1v2.n55 vss_1v2.t46 2.8079
R4121 vss_1v2.n67 vss_1v2.t46 2.8181
R4122 vss_1v2.n56 vss_1v2.t46 2.81698
R4123 vss_1v2.n66 vss_1v2.t46 2.80752
R4124 vss_1v2.n65 vss_1v2.t46 1.16992
R4125 vss_1v2.n58 vss_1v2.t46 2.82286
R4126 vss_1v2.n64 vss_1v2.t46 2.80492
R4127 vss_1v2.n59 vss_1v2.t46 2.79814
R4128 vss_1v2.n63 vss_1v2.t46 2.82707
R4129 vss_1v2.n60 vss_1v2.t46 1.4059
R4130 vss_1v2.n62 vss_1v2.t46 2.82347
R4131 vss_1v2.n61 vss_1v2.t46 2.81839
R4132 vss_1v2.n148 vss_1v2.t46 2.82607
R4133 vss_1v2.n147 vss_1v2.t46 2.82918
R4134 vss_1v2.n146 vss_1v2.t46 2.8318
R4135 vss_1v2.n145 vss_1v2.t46 2.80529
R4136 vss_1v2.n144 vss_1v2.t46 2.81821
R4137 vss_1v2.n143 vss_1v2.t46 2.82993
R4138 vss_1v2.n142 vss_1v2.t46 2.83291
R4139 vss_1v2.n141 vss_1v2.t46 2.80287
R4140 vss_1v2.n140 vss_1v2.t46 2.8323
R4141 vss_1v2.n139 vss_1v2.t46 1.35424
R4142 vss_1v2.n138 vss_1v2.t46 2.8314
R4143 vss_1v2.n136 vss_1v2.t46 1.68244
R4144 vss_1v2.n134 vss_1v2.t46 1.39564
R4145 vss_1v2.n133 vss_1v2.t46 1.62255
R4146 vss_1v2.n132 vss_1v2.t46 1.69749
R4147 vss_1v2.n131 vss_1v2.t46 1.67468
R4148 vss_1v2.n130 vss_1v2.t46 1.69571
R4149 vss_1v2.n129 vss_1v2.t46 2.82547
R4150 vss_1v2.n128 vss_1v2.t46 1.38594
R4151 vss_1v2.n127 vss_1v2.t46 1.69871
R4152 vss_1v2.n126 vss_1v2.t46 1.69657
R4153 vss_1v2.n125 vss_1v2.t46 1.68035
R4154 vss_1v2.n124 vss_1v2.n16 0.899103
R4155 vss_1v2.n123 vss_1v2.t46 2.11834
R4156 vss_1v2.n122 vss_1v2.t46 1.69406
R4157 vss_1v2.n121 vss_1v2.t46 1.64408
R4158 vss_1v2.n120 vss_1v2.t46 1.69002
R4159 vss_1v2.n118 vss_1v2.t46 2.81185
R4160 vss_1v2.n117 vss_1v2.t46 1.69083
R4161 vss_1v2.n116 vss_1v2.t46 1.68178
R4162 vss_1v2.n115 vss_1v2.t46 1.66203
R4163 vss_1v2.n114 vss_1v2.t46 1.66888
R4164 vss_1v2.n113 vss_1v2.t46 2.82693
R4165 vss_1v2.n112 vss_1v2.t46 1.37779
R4166 vss_1v2.n111 vss_1v2.t46 1.65173
R4167 vss_1v2.n110 vss_1v2.t46 1.65409
R4168 vss_1v2.n109 vss_1v2.t46 1.6786
R4169 vss_1v2.n107 vss_1v2.t46 2.82529
R4170 vss_1v2.n106 vss_1v2.t46 1.67891
R4171 vss_1v2.n105 vss_1v2.t46 1.67479
R4172 vss_1v2.n104 vss_1v2.t46 1.6927
R4173 vss_1v2.n103 vss_1v2.t46 1.62339
R4174 vss_1v2.n102 vss_1v2.t46 1.39269
R4175 vss_1v2.n101 vss_1v2.t46 1.39734
R4176 vss_1v2.n100 vss_1v2.t46 1.69666
R4177 vss_1v2.n99 vss_1v2.t46 1.68841
R4178 vss_1v2.n98 vss_1v2.t46 1.69422
R4179 vss_1v2.n96 vss_1v2.t46 1.28869
R4180 vss_1v2.n95 vss_1v2.t46 1.68897
R4181 vss_1v2.n94 vss_1v2.t46 1.65837
R4182 vss_1v2.n93 vss_1v2.t46 1.69059
R4183 vss_1v2.n92 vss_1v2.t46 1.69402
R4184 vss_1v2.n91 vss_1v2.t46 1.4
R4185 vss_1v2.n90 vss_1v2.t46 1.36571
R4186 vss_1v2.n89 vss_1v2.t46 1.20598
R4187 vss_1v2.n88 vss_1v2.t46 1.6783
R4188 vss_1v2.n87 vss_1v2.t46 1.38025
R4189 vss_1v2.n208 vss_1v2.n29 0.399806
R4190 vss_1v2.t46 vss_1v2.n26 1.65842
R4191 vss_1v2.t46 vss_1v2.n4112 8.5005
R4192 vss_1v2.t46 vss_1v2.n30 0.387069
R4193 vss_1v2.n22 vss_1v2.n4130 0.448003
R4194 vss_1v2.t46 vss_1v2.n161 2.82887
R4195 vss_1v2.t46 vss_1v2.n137 1.65598
R4196 vss_1v2.t46 vss_1v2.n25 0.407153
R4197 vss_1v2.n79 vss_1v2.t46 2.80983
R4198 vss_1v2.n52 vss_1v2.t46 2.09301
R4199 vss_1v2.t46 vss_1v2.n23 2.09313
R4200 vss_1v2.n2 vss_1v2.n188 1.17275
R4201 vss_1v2.n2 vss_1v2.n177 0.89525
R4202 vss_1v2.n2 vss_1v2.n166 0.899524
R4203 vss_1v2.n2 vss_1v2.n57 1.35724
R4204 vss_1v2.n2 vss_1v2.n135 1.68323
R4205 vss_1v2.t46 vss_1v2.n97 1.69645
R4206 vss_1v2.n25 vss_1v2.n4117 0.0980967
R4207 vss_1v2.n4088 vss_1v2.n4075 8.5005
R4208 vss_1v2.n4088 vss_1v2.n4076 8.5005
R4209 vss_1v2.n4088 vss_1v2.n264 8.5005
R4210 vss_1v2.n265 vss_1v2.n264 8.5005
R4211 vss_1v2.n265 vss_1v2.n263 8.5005
R4212 vss_1v2.n3243 vss_1v2.n462 8.49433
R4213 vss_1v2.n3245 vss_1v2.n462 8.49433
R4214 vss_1v2.n3247 vss_1v2.n462 8.49433
R4215 vss_1v2.n3249 vss_1v2.n462 8.49433
R4216 vss_1v2.n3251 vss_1v2.n462 8.49433
R4217 vss_1v2.n3253 vss_1v2.n462 8.49433
R4218 vss_1v2.n3255 vss_1v2.n462 8.49433
R4219 vss_1v2.n3257 vss_1v2.n462 8.49433
R4220 vss_1v2.n3259 vss_1v2.n462 8.49433
R4221 vss_1v2.n3261 vss_1v2.n462 8.49433
R4222 vss_1v2.n3263 vss_1v2.n462 8.49433
R4223 vss_1v2.n3265 vss_1v2.n462 8.49433
R4224 vss_1v2.n3267 vss_1v2.n462 8.49433
R4225 vss_1v2.n3269 vss_1v2.n462 8.49433
R4226 vss_1v2.n3271 vss_1v2.n462 8.49433
R4227 vss_1v2.n3273 vss_1v2.n462 8.49433
R4228 vss_1v2.n3275 vss_1v2.n462 8.49433
R4229 vss_1v2.n3277 vss_1v2.n462 8.49433
R4230 vss_1v2.n3279 vss_1v2.n462 8.49433
R4231 vss_1v2.n3281 vss_1v2.n462 8.49433
R4232 vss_1v2.n3283 vss_1v2.n462 8.49433
R4233 vss_1v2.n3285 vss_1v2.n462 8.49433
R4234 vss_1v2.n3287 vss_1v2.n462 8.49433
R4235 vss_1v2.n3289 vss_1v2.n462 8.49433
R4236 vss_1v2.n3291 vss_1v2.n462 8.49433
R4237 vss_1v2.n3293 vss_1v2.n462 8.49433
R4238 vss_1v2.n3295 vss_1v2.n462 8.49433
R4239 vss_1v2.n3297 vss_1v2.n462 8.49433
R4240 vss_1v2.n3299 vss_1v2.n462 8.49433
R4241 vss_1v2.n3301 vss_1v2.n462 8.49433
R4242 vss_1v2.n3303 vss_1v2.n462 8.49433
R4243 vss_1v2.n3305 vss_1v2.n462 8.49433
R4244 vss_1v2.n3307 vss_1v2.n462 8.49433
R4245 vss_1v2.n3309 vss_1v2.n462 8.49433
R4246 vss_1v2.n3189 vss_1v2.n3188 8.49211
R4247 vss_1v2.n4085 vss_1v2.n265 8.4714
R4248 vss_1v2.n3183 vss_1v2.n3182 8.46995
R4249 vss_1v2.n3010 vss_1v2.n3003 8.46995
R4250 vss_1v2.n2997 vss_1v2.n3002 8.46995
R4251 vss_1v2.n3030 vss_1v2.n3120 8.46995
R4252 vss_1v2.n3040 vss_1v2.n3048 8.46995
R4253 vss_1v2.n3050 vss_1v2.n3039 8.46995
R4254 vss_1v2.n82 vss_1v2.n80 0.88839
R4255 vss_1v2.n80 vss_1v2.n1995 8.46995
R4256 vss_1v2.n3173 vss_1v2.n49 0.567348
R4257 vss_1v2.n209 vss_1v2.n16 4.19865
R4258 vss_1v2.n3020 vss_1v2.n16 8.46995
R4259 vss_1v2.n3077 vss_1v2.n34 0.732027
R4260 vss_1v2.n4042 vss_1v2.n2 8.46995
R4261 vss_1v2.n4035 vss_1v2.n83 0.565716
R4262 vss_1v2.n4093 vss_1v2.n4088 8.46995
R4263 vss_1v2.n4082 vss_1v2.n265 8.46995
R4264 vss_1v2.n77 vss_1v2.n2442 0.828643
R4265 vss_1v2.n3192 vss_1v2.n3191 8.46376
R4266 vss_1v2.n3548 vss_1v2.t59 8.38866
R4267 vss_1v2.n3542 vss_1v2.n2855 8.38866
R4268 vss_1v2.n3517 vss_1v2.n1992 8.38866
R4269 vss_1v2.n3517 vss_1v2.n3516 8.38866
R4270 vss_1v2.n3516 vss_1v2.n2865 8.38866
R4271 vss_1v2.n3510 vss_1v2.n2865 8.38866
R4272 vss_1v2.n3510 vss_1v2.n3509 8.38866
R4273 vss_1v2.n2924 vss_1v2.t62 8.38866
R4274 vss_1v2.n2920 vss_1v2.n2919 8.38866
R4275 vss_1v2.t45 vss_1v2.t311 7.9832
R4276 vss_1v2.t8 vss_1v2.n1891 7.81336
R4277 vss_1v2.t61 vss_1v2.n3538 7.64853
R4278 vss_1v2.t64 vss_1v2.n2917 7.52517
R4279 vss_1v2.t77 vss_1v2.n4055 7.48375
R4280 vss_1v2.t102 vss_1v2.n4059 7.48375
R4281 vss_1v2.n1955 vss_1v2.t84 7.48375
R4282 vss_1v2.n4114 vss_1v2.t69 7.48375
R4283 vss_1v2.t140 vss_1v2.n1960 7.48375
R4284 vss_1v2.t131 vss_1v2.n1916 7.48375
R4285 vss_1v2.t122 vss_1v2.n1930 7.48375
R4286 vss_1v2.t113 vss_1v2.n1937 7.48375
R4287 vss_1v2.t75 vss_1v2.n1943 7.48375
R4288 vss_1v2.t193 vss_1v2.n3177 7.42386
R4289 vss_1v2.t142 vss_1v2.n2843 7.40375
R4290 vss_1v2.t100 vss_1v2.n2819 7.40375
R4291 vss_1v2.n2998 vss_1v2.t182 7.40375
R4292 vss_1v2.n3137 vss_1v2.t184 7.40375
R4293 vss_1v2.t188 vss_1v2.n3227 7.40375
R4294 vss_1v2.n3042 vss_1v2.t159 7.40375
R4295 vss_1v2.n1962 vss_1v2.t152 7.40375
R4296 vss_1v2.n3458 vss_1v2.t214 7.40375
R4297 vss_1v2.n3449 vss_1v2.t209 7.40375
R4298 vss_1v2.n2974 vss_1v2.t252 7.40375
R4299 vss_1v2.n3349 vss_1v2.t259 7.40375
R4300 vss_1v2.n1984 vss_1v2.t212 7.40375
R4301 vss_1v2.n2812 vss_1v2.t219 7.40375
R4302 vss_1v2.n2989 vss_1v2.t250 7.40375
R4303 vss_1v2.n3220 vss_1v2.t257 7.40375
R4304 vss_1v2.n59 vss_1v2.n792 7.29724
R4305 vss_1v2.n2915 vss_1v2.n2914 7.27846
R4306 vss_1v2.n2857 vss_1v2.n2856 7.09871
R4307 vss_1v2.n246 vss_1v2.n557 6.81647
R4308 vss_1v2.n245 vss_1v2.n873 6.81647
R4309 vss_1v2.n243 vss_1v2.n875 6.81647
R4310 vss_1v2.n242 vss_1v2.n553 6.81647
R4311 vss_1v2.n240 vss_1v2.n551 6.81647
R4312 vss_1v2.n239 vss_1v2.n879 6.81647
R4313 vss_1v2.n237 vss_1v2.n881 6.81647
R4314 vss_1v2.n236 vss_1v2.n547 6.81647
R4315 vss_1v2.n235 vss_1v2.n883 6.81647
R4316 vss_1v2.n234 vss_1v2.n545 6.81647
R4317 vss_1v2.n233 vss_1v2.n885 6.81647
R4318 vss_1v2.n232 vss_1v2.n543 6.81647
R4319 vss_1v2.n231 vss_1v2.n887 6.81647
R4320 vss_1v2.n230 vss_1v2.n541 6.81647
R4321 vss_1v2.n229 vss_1v2.n889 6.81647
R4322 vss_1v2.n227 vss_1v2.n891 6.81647
R4323 vss_1v2.n226 vss_1v2.n537 6.81647
R4324 vss_1v2.n225 vss_1v2.n893 6.81647
R4325 vss_1v2.n224 vss_1v2.n535 6.81647
R4326 vss_1v2.n2498 vss_1v2.n310 6.78504
R4327 vss_1v2.n2497 vss_1v2.n268 6.78504
R4328 vss_1v2.n2496 vss_1v2.n269 6.78504
R4329 vss_1v2.n2495 vss_1v2.n270 6.78504
R4330 vss_1v2.n2494 vss_1v2.n271 6.78504
R4331 vss_1v2.n2492 vss_1v2.n273 6.78504
R4332 vss_1v2.n2490 vss_1v2.n275 6.78504
R4333 vss_1v2.n2489 vss_1v2.n276 6.78504
R4334 vss_1v2.n2486 vss_1v2.n279 6.78504
R4335 vss_1v2.n2485 vss_1v2.n280 6.78504
R4336 vss_1v2.n2484 vss_1v2.n281 6.78504
R4337 vss_1v2.n2482 vss_1v2.n283 6.78504
R4338 vss_1v2.n2481 vss_1v2.n284 6.78504
R4339 vss_1v2.n2479 vss_1v2.n286 6.78504
R4340 vss_1v2.n2478 vss_1v2.n287 6.78504
R4341 vss_1v2.n2476 vss_1v2.n289 6.78504
R4342 vss_1v2.n2475 vss_1v2.n290 6.78504
R4343 vss_1v2.n2474 vss_1v2.n291 6.78504
R4344 vss_1v2.n2473 vss_1v2.n292 6.78504
R4345 vss_1v2.n2472 vss_1v2.n293 6.78504
R4346 vss_1v2.n2471 vss_1v2.n294 6.78504
R4347 vss_1v2.n2470 vss_1v2.n295 6.78504
R4348 vss_1v2.n2469 vss_1v2.n296 6.78504
R4349 vss_1v2.n2466 vss_1v2.n299 6.78504
R4350 vss_1v2.n2465 vss_1v2.n300 6.78504
R4351 vss_1v2.n2464 vss_1v2.n301 6.78504
R4352 vss_1v2.n2463 vss_1v2.n302 6.78504
R4353 vss_1v2.n3545 vss_1v2.n3544 6.66168
R4354 vss_1v2.n2923 vss_1v2.n2922 6.53833
R4355 vss_1v2.n1223 vss_1v2.n934 6.41497
R4356 vss_1v2.t287 vss_1v2.n274 6.41497
R4357 vss_1v2.n1007 vss_1v2.n858 6.32961
R4358 vss_1v2.n259 vss_1v2.n571 6.32961
R4359 vss_1v2.n258 vss_1v2.n860 6.32961
R4360 vss_1v2.n257 vss_1v2.n569 6.32961
R4361 vss_1v2.n255 vss_1v2.n567 6.32961
R4362 vss_1v2.n254 vss_1v2.n864 6.32961
R4363 vss_1v2.n252 vss_1v2.n866 6.32961
R4364 vss_1v2.n250 vss_1v2.n868 6.32961
R4365 vss_1v2.n249 vss_1v2.n561 6.32961
R4366 vss_1v2.n222 vss_1v2.n533 6.32961
R4367 vss_1v2.n1336 vss_1v2.n897 6.32961
R4368 vss_1v2.n1335 vss_1v2.n531 6.32961
R4369 vss_1v2.n1334 vss_1v2.n899 6.32961
R4370 vss_1v2.n1332 vss_1v2.n901 6.32961
R4371 vss_1v2.n1331 vss_1v2.n527 6.32961
R4372 vss_1v2.n1330 vss_1v2.n903 6.32961
R4373 vss_1v2.n1329 vss_1v2.n525 6.32961
R4374 vss_1v2.n1328 vss_1v2.n905 6.32961
R4375 vss_1v2.n1327 vss_1v2.n523 6.32961
R4376 vss_1v2.n1326 vss_1v2.n907 6.32961
R4377 vss_1v2.n1325 vss_1v2.n521 6.32961
R4378 vss_1v2.n1324 vss_1v2.n909 6.32961
R4379 vss_1v2.n1322 vss_1v2.n911 6.32961
R4380 vss_1v2.n1321 vss_1v2.n517 6.32961
R4381 vss_1v2.n1319 vss_1v2.n515 6.32961
R4382 vss_1v2.n1318 vss_1v2.n915 6.32961
R4383 vss_1v2.n1316 vss_1v2.n917 6.32961
R4384 vss_1v2.n1315 vss_1v2.n511 6.32961
R4385 vss_1v2.n221 vss_1v2.n919 6.32961
R4386 vss_1v2.n1312 vss_1v2.n507 6.32961
R4387 vss_1v2.n1311 vss_1v2.n923 6.32961
R4388 vss_1v2.n1309 vss_1v2.n925 6.32961
R4389 vss_1v2.n1307 vss_1v2.n927 6.32961
R4390 vss_1v2.n1306 vss_1v2.n501 6.32961
R4391 vss_1v2.n1304 vss_1v2.n499 6.32961
R4392 vss_1v2.n1300 vss_1v2.n931 6.32961
R4393 vss_1v2.n2700 vss_1v2.n312 6.29162
R4394 vss_1v2.n2703 vss_1v2.n313 6.29162
R4395 vss_1v2.n2706 vss_1v2.n314 6.29162
R4396 vss_1v2.n2709 vss_1v2.n315 6.29162
R4397 vss_1v2.n2715 vss_1v2.n317 6.29162
R4398 vss_1v2.n2718 vss_1v2.n318 6.29162
R4399 vss_1v2.n2721 vss_1v2.n319 6.29162
R4400 vss_1v2.n2724 vss_1v2.n320 6.29162
R4401 vss_1v2.n2727 vss_1v2.n321 6.29162
R4402 vss_1v2.n2730 vss_1v2.n322 6.29162
R4403 vss_1v2.n2733 vss_1v2.n323 6.29162
R4404 vss_1v2.n2736 vss_1v2.n324 6.29162
R4405 vss_1v2.n2739 vss_1v2.n325 6.29162
R4406 vss_1v2.n2745 vss_1v2.n327 6.29162
R4407 vss_1v2.n2748 vss_1v2.n328 6.29162
R4408 vss_1v2.n2754 vss_1v2.n330 6.29162
R4409 vss_1v2.n2757 vss_1v2.n331 6.29162
R4410 vss_1v2.n2763 vss_1v2.n333 6.29162
R4411 vss_1v2.n2698 vss_1v2.n334 6.29162
R4412 vss_1v2.n2766 vss_1v2.n335 6.29162
R4413 vss_1v2.n2775 vss_1v2.n338 6.29162
R4414 vss_1v2.n2778 vss_1v2.n339 6.29162
R4415 vss_1v2.n2784 vss_1v2.n341 6.29162
R4416 vss_1v2.n2790 vss_1v2.n343 6.29162
R4417 vss_1v2.n2793 vss_1v2.n344 6.29162
R4418 vss_1v2.n2799 vss_1v2.n346 6.29162
R4419 vss_1v2.n2803 vss_1v2.n347 6.29162
R4420 vss_1v2.n3484 vss_1v2.n2928 6.29162
R4421 vss_1v2.n3524 vss_1v2.n1988 6.16826
R4422 vss_1v2.n4021 vss_1v2.n1993 6.16826
R4423 vss_1v2.n3366 vss_1v2.n349 6.16826
R4424 vss_1v2.n1890 vss_1v2.n703 6.14003
R4425 vss_1v2.n1299 vss_1v2.n950 6.08619
R4426 vss_1v2.n3318 vss_1v2.n1227 6.08619
R4427 vss_1v2.n3585 vss_1v2.n2665 6.04491
R4428 vss_1v2.n3569 vss_1v2.n2692 6.04491
R4429 vss_1v2.n264 vss_1v2.t45 5.98753
R4430 vss_1v2.n3533 vss_1v2.n2862 5.92155
R4431 vss_1v2.n3534 vss_1v2.n1990 5.92155
R4432 vss_1v2.n3530 vss_1v2.n1989 5.92155
R4433 vss_1v2.t298 vss_1v2.n329 5.92155
R4434 vss_1v2.t268 vss_1v2.n871 5.84276
R4435 vss_1v2.t272 vss_1v2.n877 5.84276
R4436 vss_1v2.n1320 vss_1v2.t248 5.84276
R4437 vss_1v2.t280 vss_1v2.n505 5.84276
R4438 vss_1v2.n3124 vss_1v2.n16 2.22792
R4439 vss_1v2.n2480 vss_1v2.t295 5.7982
R4440 vss_1v2.n2781 vss_1v2.t305 5.7982
R4441 vss_1v2.n1908 vss_1v2.n1907 5.74701
R4442 vss_1v2.t4 vss_1v2.n278 5.67484
R4443 vss_1v2.n3190 vss_1v2.n1010 5.66778
R4444 vss_1v2.n4132 vss_1v2.n1288 5.66778
R4445 vss_1v2.n2982 vss_1v2.n1010 5.66778
R4446 vss_1v2.n4132 vss_1v2.n1286 5.66778
R4447 vss_1v2.n3181 vss_1v2.n1010 5.66778
R4448 vss_1v2.n3558 vss_1v2.n2831 5.66778
R4449 vss_1v2.n3235 vss_1v2.n1220 5.66778
R4450 vss_1v2.n3558 vss_1v2.n2835 5.66778
R4451 vss_1v2.n3139 vss_1v2.n1220 5.66778
R4452 vss_1v2.n4132 vss_1v2.n1284 5.66778
R4453 vss_1v2.n3009 vss_1v2.n1010 5.66778
R4454 vss_1v2.n4132 vss_1v2.n1291 5.66778
R4455 vss_1v2.n3558 vss_1v2.n2826 5.66778
R4456 vss_1v2.n3091 vss_1v2.n1220 5.66778
R4457 vss_1v2.n3558 vss_1v2.n2684 5.66778
R4458 vss_1v2.n2822 vss_1v2.n1220 5.66778
R4459 vss_1v2.n2838 vss_1v2.n1220 5.66778
R4460 vss_1v2.n3558 vss_1v2.n2825 5.66778
R4461 vss_1v2.n2849 vss_1v2.n1220 5.66778
R4462 vss_1v2.n3532 vss_1v2.n2863 5.66778
R4463 vss_1v2.n2863 vss_1v2.n2854 5.66778
R4464 vss_1v2.n3536 vss_1v2.n935 5.66778
R4465 vss_1v2.n2853 vss_1v2.n935 5.66778
R4466 vss_1v2.n3586 vss_1v2.n3585 5.66778
R4467 vss_1v2.n3569 vss_1v2.n2805 5.66778
R4468 vss_1v2.n3585 vss_1v2.n306 5.66778
R4469 vss_1v2.n3569 vss_1v2.n304 5.66778
R4470 vss_1v2.n3585 vss_1v2.n2671 5.66778
R4471 vss_1v2.n3569 vss_1v2.n2806 5.66778
R4472 vss_1v2.n3585 vss_1v2.n2676 5.66778
R4473 vss_1v2.n3569 vss_1v2.n2695 5.66778
R4474 vss_1v2.n3585 vss_1v2.n2670 5.66778
R4475 vss_1v2.n3585 vss_1v2.n2677 5.66778
R4476 vss_1v2.n3585 vss_1v2.n2666 5.66778
R4477 vss_1v2.n3569 vss_1v2.n3567 5.66778
R4478 vss_1v2.n3585 vss_1v2.n3584 5.66778
R4479 vss_1v2.n3569 vss_1v2.n2680 5.66778
R4480 vss_1v2.n2522 vss_1v2.n2517 5.66778
R4481 vss_1v2.n3835 vss_1v2.n3822 5.66778
R4482 vss_1v2.n3455 vss_1v2.n2955 5.66778
R4483 vss_1v2.n3482 vss_1v2.n2938 5.66778
R4484 vss_1v2.n3455 vss_1v2.n2958 5.66778
R4485 vss_1v2.n3482 vss_1v2.n2936 5.66778
R4486 vss_1v2.n3482 vss_1v2.n2939 5.66778
R4487 vss_1v2.n3455 vss_1v2.n2954 5.66778
R4488 vss_1v2.n3455 vss_1v2.n3393 5.66778
R4489 vss_1v2.n3482 vss_1v2.n2935 5.66778
R4490 vss_1v2.n3455 vss_1v2.n2953 5.66778
R4491 vss_1v2.n3482 vss_1v2.n2940 5.66778
R4492 vss_1v2.n3455 vss_1v2.n2905 5.66778
R4493 vss_1v2.n3482 vss_1v2.n2903 5.66778
R4494 vss_1v2.n3455 vss_1v2.n2952 5.66778
R4495 vss_1v2.n3482 vss_1v2.n2941 5.66778
R4496 vss_1v2.n3455 vss_1v2.n3434 5.66778
R4497 vss_1v2.n3482 vss_1v2.n2934 5.66778
R4498 vss_1v2.n3482 vss_1v2.n2874 5.66778
R4499 vss_1v2.n3455 vss_1v2.n2875 5.66778
R4500 vss_1v2.n3455 vss_1v2.n3454 5.66778
R4501 vss_1v2.n3482 vss_1v2.n2933 5.66778
R4502 vss_1v2.n3455 vss_1v2.n1973 5.66778
R4503 vss_1v2.n3482 vss_1v2.n2942 5.66778
R4504 vss_1v2.n3456 vss_1v2.n3455 5.66778
R4505 vss_1v2.n3482 vss_1v2.n2931 5.66778
R4506 vss_1v2.n4117 vss_1v2.n18 1.30678
R4507 vss_1v2.n14 vss_1v2.n18 0.277997
R4508 vss_1v2.n13 vss_1v2.n16 0.695427
R4509 vss_1v2.t46 vss_1v2.n29 0.296552
R4510 vss_1v2.n22 vss_1v2.t46 0.275269
R4511 vss_1v2.n3841 vss_1v2.n74 2.12576
R4512 vss_1v2.n75 vss_1v2.n74 0.00268425
R4513 vss_1v2.n4021 vss_1v2.n80 3.40114
R4514 vss_1v2.n266 vss_1v2.n265 0.00112979
R4515 vss_1v2.n1879 vss_1v2.n715 5.66767
R4516 vss_1v2.n12 vss_1v2.n4147 5.66717
R4517 vss_1v2.n12 vss_1v2.n496 5.66717
R4518 vss_1v2.n12 vss_1v2.n932 5.66717
R4519 vss_1v2.n12 vss_1v2.n498 5.66717
R4520 vss_1v2.n12 vss_1v2.n930 5.66717
R4521 vss_1v2.n12 vss_1v2.n500 5.66717
R4522 vss_1v2.n12 vss_1v2.n928 5.66717
R4523 vss_1v2.n12 vss_1v2.n502 5.66717
R4524 vss_1v2.n12 vss_1v2.n926 5.66717
R4525 vss_1v2.n12 vss_1v2.n504 5.66717
R4526 vss_1v2.n12 vss_1v2.n924 5.66717
R4527 vss_1v2.n12 vss_1v2.n506 5.66717
R4528 vss_1v2.n12 vss_1v2.n922 5.66717
R4529 vss_1v2.n12 vss_1v2.n508 5.66717
R4530 vss_1v2.n12 vss_1v2.n920 5.66717
R4531 vss_1v2.n12 vss_1v2.n510 5.66717
R4532 vss_1v2.n12 vss_1v2.n918 5.66717
R4533 vss_1v2.n12 vss_1v2.n512 5.66717
R4534 vss_1v2.n12 vss_1v2.n916 5.66717
R4535 vss_1v2.n12 vss_1v2.n514 5.66717
R4536 vss_1v2.n12 vss_1v2.n914 5.66717
R4537 vss_1v2.n12 vss_1v2.n516 5.66717
R4538 vss_1v2.n12 vss_1v2.n912 5.66717
R4539 vss_1v2.n12 vss_1v2.n518 5.66717
R4540 vss_1v2.n12 vss_1v2.n910 5.66717
R4541 vss_1v2.n12 vss_1v2.n520 5.66717
R4542 vss_1v2.n12 vss_1v2.n908 5.66717
R4543 vss_1v2.n12 vss_1v2.n522 5.66717
R4544 vss_1v2.n12 vss_1v2.n906 5.66717
R4545 vss_1v2.n12 vss_1v2.n524 5.66717
R4546 vss_1v2.n12 vss_1v2.n904 5.66717
R4547 vss_1v2.n12 vss_1v2.n526 5.66717
R4548 vss_1v2.n12 vss_1v2.n902 5.66717
R4549 vss_1v2.n12 vss_1v2.n528 5.66717
R4550 vss_1v2.n12 vss_1v2.n900 5.66717
R4551 vss_1v2.n12 vss_1v2.n530 5.66717
R4552 vss_1v2.n12 vss_1v2.n898 5.66717
R4553 vss_1v2.n12 vss_1v2.n532 5.66717
R4554 vss_1v2.n12 vss_1v2.n896 5.66717
R4555 vss_1v2.n12 vss_1v2.n534 5.66717
R4556 vss_1v2.n12 vss_1v2.n894 5.66717
R4557 vss_1v2.n12 vss_1v2.n536 5.66717
R4558 vss_1v2.n12 vss_1v2.n892 5.66717
R4559 vss_1v2.n12 vss_1v2.n538 5.66717
R4560 vss_1v2.n12 vss_1v2.n890 5.66717
R4561 vss_1v2.n12 vss_1v2.n540 5.66717
R4562 vss_1v2.n12 vss_1v2.n888 5.66717
R4563 vss_1v2.n12 vss_1v2.n542 5.66717
R4564 vss_1v2.n12 vss_1v2.n886 5.66717
R4565 vss_1v2.n12 vss_1v2.n544 5.66717
R4566 vss_1v2.n12 vss_1v2.n884 5.66717
R4567 vss_1v2.n12 vss_1v2.n546 5.66717
R4568 vss_1v2.n12 vss_1v2.n882 5.66717
R4569 vss_1v2.n12 vss_1v2.n548 5.66717
R4570 vss_1v2.n12 vss_1v2.n880 5.66717
R4571 vss_1v2.n12 vss_1v2.n550 5.66717
R4572 vss_1v2.n12 vss_1v2.n878 5.66717
R4573 vss_1v2.n12 vss_1v2.n552 5.66717
R4574 vss_1v2.n12 vss_1v2.n876 5.66717
R4575 vss_1v2.n12 vss_1v2.n554 5.66717
R4576 vss_1v2.n12 vss_1v2.n874 5.66717
R4577 vss_1v2.n12 vss_1v2.n556 5.66717
R4578 vss_1v2.n12 vss_1v2.n872 5.66717
R4579 vss_1v2.n12 vss_1v2.n558 5.66717
R4580 vss_1v2.n4148 vss_1v2.n12 5.66717
R4581 vss_1v2.n12 vss_1v2.n560 5.66717
R4582 vss_1v2.n12 vss_1v2.n869 5.66717
R4583 vss_1v2.n12 vss_1v2.n562 5.66717
R4584 vss_1v2.n12 vss_1v2.n867 5.66717
R4585 vss_1v2.n12 vss_1v2.n564 5.66717
R4586 vss_1v2.n12 vss_1v2.n865 5.66717
R4587 vss_1v2.n12 vss_1v2.n566 5.66717
R4588 vss_1v2.n12 vss_1v2.n863 5.66717
R4589 vss_1v2.n12 vss_1v2.n568 5.66717
R4590 vss_1v2.n12 vss_1v2.n861 5.66717
R4591 vss_1v2.n12 vss_1v2.n570 5.66717
R4592 vss_1v2.n12 vss_1v2.n859 5.66717
R4593 vss_1v2.n12 vss_1v2.n572 5.66717
R4594 vss_1v2.n12 vss_1v2.n434 2.8319
R4595 vss_1v2.n12 vss_1v2.n433 5.66717
R4596 vss_1v2.n12 vss_1v2.n573 5.66717
R4597 vss_1v2.n12 vss_1v2.n857 5.66717
R4598 vss_1v2.n12 vss_1v2.n575 5.66717
R4599 vss_1v2.n12 vss_1v2.n855 5.66717
R4600 vss_1v2.n12 vss_1v2.n576 5.66717
R4601 vss_1v2.n12 vss_1v2.n853 5.66717
R4602 vss_1v2.n12 vss_1v2.n578 5.66717
R4603 vss_1v2.n12 vss_1v2.n851 5.66717
R4604 vss_1v2.n12 vss_1v2.n580 5.66717
R4605 vss_1v2.n12 vss_1v2.n849 5.66717
R4606 vss_1v2.n12 vss_1v2.n582 5.66717
R4607 vss_1v2.n12 vss_1v2.n847 5.66717
R4608 vss_1v2.n12 vss_1v2.n584 5.66717
R4609 vss_1v2.n12 vss_1v2.n399 2.83186
R4610 vss_1v2.n399 vss_1v2.n397 0.00594278
R4611 vss_1v2.n12 vss_1v2.n844 5.66717
R4612 vss_1v2.n12 vss_1v2.n587 5.66717
R4613 vss_1v2.n12 vss_1v2.n842 5.66717
R4614 vss_1v2.n12 vss_1v2.n589 5.66717
R4615 vss_1v2.n12 vss_1v2.n840 5.66717
R4616 vss_1v2.n12 vss_1v2.n411 2.83186
R4617 vss_1v2.n411 vss_1v2.n409 0.00594278
R4618 vss_1v2.n12 vss_1v2.n592 5.66717
R4619 vss_1v2.n12 vss_1v2.n837 5.66717
R4620 vss_1v2.n12 vss_1v2.n594 5.66717
R4621 vss_1v2.n12 vss_1v2.n835 5.66717
R4622 vss_1v2.n12 vss_1v2.n596 5.66717
R4623 vss_1v2.n12 vss_1v2.n833 5.66717
R4624 vss_1v2.n12 vss_1v2.n598 5.66717
R4625 vss_1v2.n12 vss_1v2.n831 5.66717
R4626 vss_1v2.n12 vss_1v2.n600 5.66717
R4627 vss_1v2.n12 vss_1v2.n829 5.66717
R4628 vss_1v2.n12 vss_1v2.n602 5.66717
R4629 vss_1v2.n12 vss_1v2.n827 5.66717
R4630 vss_1v2.n12 vss_1v2.n604 5.66717
R4631 vss_1v2.n12 vss_1v2.n825 5.66717
R4632 vss_1v2.n12 vss_1v2.n606 5.66717
R4633 vss_1v2.n12 vss_1v2.n402 2.83186
R4634 vss_1v2.n402 vss_1v2.n400 0.00594278
R4635 vss_1v2.n12 vss_1v2.n822 5.66717
R4636 vss_1v2.n12 vss_1v2.n609 5.66717
R4637 vss_1v2.n12 vss_1v2.n820 5.66717
R4638 vss_1v2.n12 vss_1v2.n611 5.66717
R4639 vss_1v2.n12 vss_1v2.n818 5.66717
R4640 vss_1v2.n12 vss_1v2.n414 2.83186
R4641 vss_1v2.n414 vss_1v2.n412 0.00594278
R4642 vss_1v2.n12 vss_1v2.n614 5.66717
R4643 vss_1v2.n12 vss_1v2.n815 5.66717
R4644 vss_1v2.n12 vss_1v2.n616 5.66717
R4645 vss_1v2.n12 vss_1v2.n813 5.66717
R4646 vss_1v2.n12 vss_1v2.n618 5.66717
R4647 vss_1v2.n12 vss_1v2.n811 5.66717
R4648 vss_1v2.n12 vss_1v2.n620 5.66717
R4649 vss_1v2.n12 vss_1v2.n809 5.66717
R4650 vss_1v2.n12 vss_1v2.n622 5.66717
R4651 vss_1v2.n12 vss_1v2.n807 5.66717
R4652 vss_1v2.n12 vss_1v2.n624 5.66717
R4653 vss_1v2.n12 vss_1v2.n805 5.66717
R4654 vss_1v2.n12 vss_1v2.n626 5.66717
R4655 vss_1v2.n12 vss_1v2.n803 5.66717
R4656 vss_1v2.n12 vss_1v2.n628 5.66717
R4657 vss_1v2.n12 vss_1v2.n405 2.83186
R4658 vss_1v2.n405 vss_1v2.n403 0.00594278
R4659 vss_1v2.n12 vss_1v2.n800 5.66717
R4660 vss_1v2.n12 vss_1v2.n631 5.66717
R4661 vss_1v2.n12 vss_1v2.n798 5.66717
R4662 vss_1v2.n12 vss_1v2.n633 5.66717
R4663 vss_1v2.n12 vss_1v2.n796 5.66717
R4664 vss_1v2.n12 vss_1v2.n417 2.83186
R4665 vss_1v2.n417 vss_1v2.n415 0.00594278
R4666 vss_1v2.n12 vss_1v2.n636 5.66717
R4667 vss_1v2.n12 vss_1v2.n793 5.66717
R4668 vss_1v2.n12 vss_1v2.n638 5.66717
R4669 vss_1v2.n12 vss_1v2.n791 5.66717
R4670 vss_1v2.n12 vss_1v2.n639 5.66717
R4671 vss_1v2.n12 vss_1v2.n789 5.66717
R4672 vss_1v2.n12 vss_1v2.n641 5.66717
R4673 vss_1v2.n12 vss_1v2.n787 5.66717
R4674 vss_1v2.n12 vss_1v2.n381 2.83186
R4675 vss_1v2.n381 vss_1v2.n379 0.00594278
R4676 vss_1v2.n12 vss_1v2.n644 5.66717
R4677 vss_1v2.n12 vss_1v2.n784 5.66717
R4678 vss_1v2.n12 vss_1v2.n646 5.66717
R4679 vss_1v2.n12 vss_1v2.n782 5.66717
R4680 vss_1v2.n12 vss_1v2.n648 5.66717
R4681 vss_1v2.n12 vss_1v2.n391 2.83186
R4682 vss_1v2.n391 vss_1v2.n389 0.00594278
R4683 vss_1v2.n12 vss_1v2.n779 5.66717
R4684 vss_1v2.n12 vss_1v2.n651 5.66717
R4685 vss_1v2.n12 vss_1v2.n777 5.66717
R4686 vss_1v2.n12 vss_1v2.n653 5.66717
R4687 vss_1v2.n12 vss_1v2.n775 5.66717
R4688 vss_1v2.n12 vss_1v2.n655 5.66717
R4689 vss_1v2.n12 vss_1v2.n773 5.66717
R4690 vss_1v2.n12 vss_1v2.n657 5.66717
R4691 vss_1v2.n12 vss_1v2.n771 5.66717
R4692 vss_1v2.n12 vss_1v2.n659 5.66717
R4693 vss_1v2.n12 vss_1v2.n769 5.66717
R4694 vss_1v2.n12 vss_1v2.n661 5.66717
R4695 vss_1v2.n12 vss_1v2.n767 5.66717
R4696 vss_1v2.n12 vss_1v2.n663 5.66717
R4697 vss_1v2.n12 vss_1v2.n765 5.66717
R4698 vss_1v2.n12 vss_1v2.n384 2.83186
R4699 vss_1v2.n384 vss_1v2.n382 0.00594278
R4700 vss_1v2.n12 vss_1v2.n666 5.66717
R4701 vss_1v2.n12 vss_1v2.n762 5.66717
R4702 vss_1v2.n12 vss_1v2.n668 5.66717
R4703 vss_1v2.n12 vss_1v2.n760 5.66717
R4704 vss_1v2.n12 vss_1v2.n670 5.66717
R4705 vss_1v2.n12 vss_1v2.n394 2.83186
R4706 vss_1v2.n394 vss_1v2.n392 0.00594278
R4707 vss_1v2.n12 vss_1v2.n757 5.66717
R4708 vss_1v2.n12 vss_1v2.n673 5.66717
R4709 vss_1v2.n12 vss_1v2.n755 5.66717
R4710 vss_1v2.n12 vss_1v2.n675 5.66717
R4711 vss_1v2.n12 vss_1v2.n753 5.66717
R4712 vss_1v2.n12 vss_1v2.n677 5.66717
R4713 vss_1v2.n12 vss_1v2.n751 5.66717
R4714 vss_1v2.n12 vss_1v2.n679 5.66717
R4715 vss_1v2.n12 vss_1v2.n749 5.66717
R4716 vss_1v2.n12 vss_1v2.n681 5.66717
R4717 vss_1v2.n12 vss_1v2.n747 5.66717
R4718 vss_1v2.n12 vss_1v2.n683 5.66717
R4719 vss_1v2.n12 vss_1v2.n745 5.66717
R4720 vss_1v2.n12 vss_1v2.n685 5.66717
R4721 vss_1v2.n12 vss_1v2.n743 5.66717
R4722 vss_1v2.n12 vss_1v2.n387 2.83186
R4723 vss_1v2.n387 vss_1v2.n385 0.00594278
R4724 vss_1v2.n12 vss_1v2.n688 5.66717
R4725 vss_1v2.n12 vss_1v2.n740 5.66717
R4726 vss_1v2.n12 vss_1v2.n690 5.66717
R4727 vss_1v2.n12 vss_1v2.n738 5.66717
R4728 vss_1v2.n12 vss_1v2.n692 5.66717
R4729 vss_1v2.n12 vss_1v2.n736 5.66717
R4730 vss_1v2.n12 vss_1v2.n694 5.66717
R4731 vss_1v2.n12 vss_1v2.n734 5.66717
R4732 vss_1v2.n12 vss_1v2.n696 5.66717
R4733 vss_1v2.n12 vss_1v2.n732 5.66717
R4734 vss_1v2.n12 vss_1v2.n698 5.66717
R4735 vss_1v2.n12 vss_1v2.n730 5.66717
R4736 vss_1v2.n12 vss_1v2.n700 5.66717
R4737 vss_1v2.n12 vss_1v2.n937 5.66717
R4738 vss_1v2.n12 vss_1v2.n497 5.66717
R4739 vss_1v2.n12 vss_1v2.n931 5.66717
R4740 vss_1v2.n12 vss_1v2.n499 5.66717
R4741 vss_1v2.n12 vss_1v2.n929 5.66717
R4742 vss_1v2.n12 vss_1v2.n501 5.66717
R4743 vss_1v2.n12 vss_1v2.n927 5.66717
R4744 vss_1v2.n12 vss_1v2.n503 5.66717
R4745 vss_1v2.n12 vss_1v2.n925 5.66717
R4746 vss_1v2.n12 vss_1v2.n505 5.66717
R4747 vss_1v2.n12 vss_1v2.n923 5.66717
R4748 vss_1v2.n12 vss_1v2.n507 5.66717
R4749 vss_1v2.n12 vss_1v2.n921 5.66717
R4750 vss_1v2.n12 vss_1v2.n509 5.66717
R4751 vss_1v2.n12 vss_1v2.n919 5.66717
R4752 vss_1v2.n12 vss_1v2.n511 5.66717
R4753 vss_1v2.n12 vss_1v2.n917 5.66717
R4754 vss_1v2.n12 vss_1v2.n513 5.66717
R4755 vss_1v2.n12 vss_1v2.n915 5.66717
R4756 vss_1v2.n12 vss_1v2.n515 5.66717
R4757 vss_1v2.n12 vss_1v2.n913 5.66717
R4758 vss_1v2.n12 vss_1v2.n517 5.66717
R4759 vss_1v2.n12 vss_1v2.n911 5.66717
R4760 vss_1v2.n12 vss_1v2.n519 5.66717
R4761 vss_1v2.n12 vss_1v2.n909 5.66717
R4762 vss_1v2.n12 vss_1v2.n521 5.66717
R4763 vss_1v2.n12 vss_1v2.n907 5.66717
R4764 vss_1v2.n12 vss_1v2.n523 5.66717
R4765 vss_1v2.n12 vss_1v2.n905 5.66717
R4766 vss_1v2.n12 vss_1v2.n525 5.66717
R4767 vss_1v2.n12 vss_1v2.n903 5.66717
R4768 vss_1v2.n12 vss_1v2.n527 5.66717
R4769 vss_1v2.n12 vss_1v2.n901 5.66717
R4770 vss_1v2.n12 vss_1v2.n529 5.66717
R4771 vss_1v2.n12 vss_1v2.n899 5.66717
R4772 vss_1v2.n12 vss_1v2.n531 5.66717
R4773 vss_1v2.n12 vss_1v2.n897 5.66717
R4774 vss_1v2.n12 vss_1v2.n533 5.66717
R4775 vss_1v2.n12 vss_1v2.n895 5.66717
R4776 vss_1v2.n12 vss_1v2.n535 5.66717
R4777 vss_1v2.n12 vss_1v2.n893 5.66717
R4778 vss_1v2.n12 vss_1v2.n537 5.66717
R4779 vss_1v2.n12 vss_1v2.n891 5.66717
R4780 vss_1v2.n12 vss_1v2.n539 5.66717
R4781 vss_1v2.n12 vss_1v2.n889 5.66717
R4782 vss_1v2.n12 vss_1v2.n541 5.66717
R4783 vss_1v2.n12 vss_1v2.n887 5.66717
R4784 vss_1v2.n12 vss_1v2.n543 5.66717
R4785 vss_1v2.n12 vss_1v2.n885 5.66717
R4786 vss_1v2.n12 vss_1v2.n545 5.66717
R4787 vss_1v2.n12 vss_1v2.n883 5.66717
R4788 vss_1v2.n12 vss_1v2.n547 5.66717
R4789 vss_1v2.n12 vss_1v2.n881 5.66717
R4790 vss_1v2.n12 vss_1v2.n549 5.66717
R4791 vss_1v2.n12 vss_1v2.n879 5.66717
R4792 vss_1v2.n12 vss_1v2.n551 5.66717
R4793 vss_1v2.n12 vss_1v2.n877 5.66717
R4794 vss_1v2.n12 vss_1v2.n553 5.66717
R4795 vss_1v2.n12 vss_1v2.n875 5.66717
R4796 vss_1v2.n12 vss_1v2.n555 5.66717
R4797 vss_1v2.n12 vss_1v2.n873 5.66717
R4798 vss_1v2.n12 vss_1v2.n557 5.66717
R4799 vss_1v2.n12 vss_1v2.n871 5.66717
R4800 vss_1v2.n12 vss_1v2.n559 5.66717
R4801 vss_1v2.n12 vss_1v2.n870 5.66717
R4802 vss_1v2.n12 vss_1v2.n561 5.66717
R4803 vss_1v2.n12 vss_1v2.n868 5.66717
R4804 vss_1v2.n12 vss_1v2.n563 5.66717
R4805 vss_1v2.n12 vss_1v2.n866 5.66717
R4806 vss_1v2.n12 vss_1v2.n565 5.66717
R4807 vss_1v2.n12 vss_1v2.n864 5.66717
R4808 vss_1v2.n12 vss_1v2.n567 5.66717
R4809 vss_1v2.n12 vss_1v2.n862 5.66717
R4810 vss_1v2.n12 vss_1v2.n569 5.66717
R4811 vss_1v2.n12 vss_1v2.n860 5.66717
R4812 vss_1v2.n12 vss_1v2.n571 5.66717
R4813 vss_1v2.n12 vss_1v2.n858 5.66717
R4814 vss_1v2.n12 vss_1v2.n856 5.66717
R4815 vss_1v2.n12 vss_1v2.n854 5.66717
R4816 vss_1v2.n12 vss_1v2.n577 5.66717
R4817 vss_1v2.n12 vss_1v2.n852 5.66717
R4818 vss_1v2.n12 vss_1v2.n579 5.66717
R4819 vss_1v2.n12 vss_1v2.n850 5.66717
R4820 vss_1v2.n12 vss_1v2.n581 5.66717
R4821 vss_1v2.n12 vss_1v2.n848 5.66717
R4822 vss_1v2.n12 vss_1v2.n583 5.66717
R4823 vss_1v2.n12 vss_1v2.n846 5.66717
R4824 vss_1v2.n12 vss_1v2.n585 5.66717
R4825 vss_1v2.n12 vss_1v2.n845 5.66717
R4826 vss_1v2.n12 vss_1v2.n586 5.66717
R4827 vss_1v2.n12 vss_1v2.n843 5.66717
R4828 vss_1v2.n12 vss_1v2.n588 5.66717
R4829 vss_1v2.n12 vss_1v2.n841 5.66717
R4830 vss_1v2.n12 vss_1v2.n590 5.66717
R4831 vss_1v2.n12 vss_1v2.n839 5.66717
R4832 vss_1v2.n12 vss_1v2.n591 5.66717
R4833 vss_1v2.n12 vss_1v2.n838 5.66717
R4834 vss_1v2.n12 vss_1v2.n593 5.66717
R4835 vss_1v2.n12 vss_1v2.n836 5.66717
R4836 vss_1v2.n12 vss_1v2.n595 5.66717
R4837 vss_1v2.n12 vss_1v2.n834 5.66717
R4838 vss_1v2.n12 vss_1v2.n597 5.66717
R4839 vss_1v2.n12 vss_1v2.n832 5.66717
R4840 vss_1v2.n12 vss_1v2.n599 5.66717
R4841 vss_1v2.n12 vss_1v2.n830 5.66717
R4842 vss_1v2.n12 vss_1v2.n601 5.66717
R4843 vss_1v2.n12 vss_1v2.n828 5.66717
R4844 vss_1v2.n12 vss_1v2.n603 5.66717
R4845 vss_1v2.n12 vss_1v2.n826 5.66717
R4846 vss_1v2.n12 vss_1v2.n605 5.66717
R4847 vss_1v2.n12 vss_1v2.n824 5.66717
R4848 vss_1v2.n12 vss_1v2.n607 5.66717
R4849 vss_1v2.n12 vss_1v2.n823 5.66717
R4850 vss_1v2.n12 vss_1v2.n608 5.66717
R4851 vss_1v2.n12 vss_1v2.n821 5.66717
R4852 vss_1v2.n12 vss_1v2.n610 5.66717
R4853 vss_1v2.n12 vss_1v2.n819 5.66717
R4854 vss_1v2.n12 vss_1v2.n612 5.66717
R4855 vss_1v2.n12 vss_1v2.n817 5.66717
R4856 vss_1v2.n12 vss_1v2.n613 5.66717
R4857 vss_1v2.n12 vss_1v2.n816 5.66717
R4858 vss_1v2.n12 vss_1v2.n615 5.66717
R4859 vss_1v2.n12 vss_1v2.n814 5.66717
R4860 vss_1v2.n12 vss_1v2.n617 5.66717
R4861 vss_1v2.n12 vss_1v2.n812 5.66717
R4862 vss_1v2.n12 vss_1v2.n619 5.66717
R4863 vss_1v2.n12 vss_1v2.n810 5.66717
R4864 vss_1v2.n12 vss_1v2.n621 5.66717
R4865 vss_1v2.n12 vss_1v2.n808 5.66717
R4866 vss_1v2.n12 vss_1v2.n623 5.66717
R4867 vss_1v2.n12 vss_1v2.n806 5.66717
R4868 vss_1v2.n12 vss_1v2.n625 5.66717
R4869 vss_1v2.n12 vss_1v2.n804 5.66717
R4870 vss_1v2.n12 vss_1v2.n627 5.66717
R4871 vss_1v2.n12 vss_1v2.n802 5.66717
R4872 vss_1v2.n12 vss_1v2.n629 5.66717
R4873 vss_1v2.n12 vss_1v2.n801 5.66717
R4874 vss_1v2.n12 vss_1v2.n630 5.66717
R4875 vss_1v2.n12 vss_1v2.n799 5.66717
R4876 vss_1v2.n12 vss_1v2.n632 5.66717
R4877 vss_1v2.n12 vss_1v2.n797 5.66717
R4878 vss_1v2.n12 vss_1v2.n634 5.66717
R4879 vss_1v2.n12 vss_1v2.n795 5.66717
R4880 vss_1v2.n12 vss_1v2.n635 5.66717
R4881 vss_1v2.n12 vss_1v2.n794 5.66717
R4882 vss_1v2.n12 vss_1v2.n637 5.66717
R4883 vss_1v2.n12 vss_1v2.n790 5.66717
R4884 vss_1v2.n12 vss_1v2.n640 5.66717
R4885 vss_1v2.n12 vss_1v2.n788 5.66717
R4886 vss_1v2.n12 vss_1v2.n642 5.66717
R4887 vss_1v2.n12 vss_1v2.n786 5.66717
R4888 vss_1v2.n12 vss_1v2.n643 5.66717
R4889 vss_1v2.n12 vss_1v2.n785 5.66717
R4890 vss_1v2.n12 vss_1v2.n645 5.66717
R4891 vss_1v2.n12 vss_1v2.n783 5.66717
R4892 vss_1v2.n12 vss_1v2.n647 5.66717
R4893 vss_1v2.n12 vss_1v2.n781 5.66717
R4894 vss_1v2.n12 vss_1v2.n649 5.66717
R4895 vss_1v2.n12 vss_1v2.n780 5.66717
R4896 vss_1v2.n12 vss_1v2.n650 5.66717
R4897 vss_1v2.n12 vss_1v2.n778 5.66717
R4898 vss_1v2.n12 vss_1v2.n652 5.66717
R4899 vss_1v2.n12 vss_1v2.n776 5.66717
R4900 vss_1v2.n12 vss_1v2.n654 5.66717
R4901 vss_1v2.n12 vss_1v2.n774 5.66717
R4902 vss_1v2.n12 vss_1v2.n656 5.66717
R4903 vss_1v2.n12 vss_1v2.n772 5.66717
R4904 vss_1v2.n12 vss_1v2.n658 5.66717
R4905 vss_1v2.n12 vss_1v2.n770 5.66717
R4906 vss_1v2.n12 vss_1v2.n660 5.66717
R4907 vss_1v2.n12 vss_1v2.n768 5.66717
R4908 vss_1v2.n12 vss_1v2.n662 5.66717
R4909 vss_1v2.n12 vss_1v2.n766 5.66717
R4910 vss_1v2.n12 vss_1v2.n664 5.66717
R4911 vss_1v2.n12 vss_1v2.n764 5.66717
R4912 vss_1v2.n12 vss_1v2.n665 5.66717
R4913 vss_1v2.n12 vss_1v2.n763 5.66717
R4914 vss_1v2.n12 vss_1v2.n667 5.66717
R4915 vss_1v2.n12 vss_1v2.n761 5.66717
R4916 vss_1v2.n12 vss_1v2.n669 5.66717
R4917 vss_1v2.n12 vss_1v2.n759 5.66717
R4918 vss_1v2.n12 vss_1v2.n671 5.66717
R4919 vss_1v2.n12 vss_1v2.n758 5.66717
R4920 vss_1v2.n12 vss_1v2.n672 5.66717
R4921 vss_1v2.n12 vss_1v2.n756 5.66717
R4922 vss_1v2.n12 vss_1v2.n674 5.66717
R4923 vss_1v2.n12 vss_1v2.n754 5.66717
R4924 vss_1v2.n12 vss_1v2.n676 5.66717
R4925 vss_1v2.n12 vss_1v2.n752 5.66717
R4926 vss_1v2.n12 vss_1v2.n678 5.66717
R4927 vss_1v2.n12 vss_1v2.n750 5.66717
R4928 vss_1v2.n12 vss_1v2.n680 5.66717
R4929 vss_1v2.n12 vss_1v2.n748 5.66717
R4930 vss_1v2.n12 vss_1v2.n682 5.66717
R4931 vss_1v2.n12 vss_1v2.n746 5.66717
R4932 vss_1v2.n12 vss_1v2.n684 5.66717
R4933 vss_1v2.n12 vss_1v2.n744 5.66717
R4934 vss_1v2.n12 vss_1v2.n686 5.66717
R4935 vss_1v2.n12 vss_1v2.n742 5.66717
R4936 vss_1v2.n12 vss_1v2.n687 5.66717
R4937 vss_1v2.n12 vss_1v2.n741 5.66717
R4938 vss_1v2.n12 vss_1v2.n689 5.66717
R4939 vss_1v2.n12 vss_1v2.n739 5.66717
R4940 vss_1v2.n12 vss_1v2.n691 5.66717
R4941 vss_1v2.n12 vss_1v2.n737 5.66717
R4942 vss_1v2.n12 vss_1v2.n693 5.66717
R4943 vss_1v2.n12 vss_1v2.n735 5.66717
R4944 vss_1v2.n12 vss_1v2.n695 5.66717
R4945 vss_1v2.n12 vss_1v2.n733 5.66717
R4946 vss_1v2.n12 vss_1v2.n697 5.66717
R4947 vss_1v2.n12 vss_1v2.n731 5.66717
R4948 vss_1v2.n12 vss_1v2.n699 5.66717
R4949 vss_1v2.n12 vss_1v2.n729 5.66717
R4950 vss_1v2.n12 vss_1v2.n701 5.66717
R4951 vss_1v2.n2665 vss_1v2.n418 5.66717
R4952 vss_1v2.n3509 vss_1v2.n3508 5.66717
R4953 vss_1v2.n3511 vss_1v2.n3510 5.66717
R4954 vss_1v2.n3513 vss_1v2.n2865 5.66717
R4955 vss_1v2.n3516 vss_1v2.n3515 5.66717
R4956 vss_1v2.n3518 vss_1v2.n3517 5.66717
R4957 vss_1v2.n3520 vss_1v2.n1992 5.66717
R4958 vss_1v2.n3522 vss_1v2.n1993 5.66717
R4959 vss_1v2.n3525 vss_1v2.n3524 5.66717
R4960 vss_1v2.n3528 vss_1v2.n3527 5.66717
R4961 vss_1v2.n3531 vss_1v2.n3530 5.66717
R4962 vss_1v2.n3535 vss_1v2.n3534 5.66717
R4963 vss_1v2.n3535 vss_1v2.n2862 5.66717
R4964 vss_1v2.n3538 vss_1v2.n3537 5.66717
R4965 vss_1v2.n2859 vss_1v2.n2855 5.66717
R4966 vss_1v2.n3543 vss_1v2.n3542 5.66717
R4967 vss_1v2.n3544 vss_1v2.n3543 5.66717
R4968 vss_1v2.n2852 vss_1v2.t59 5.66717
R4969 vss_1v2.n3549 vss_1v2.n3548 5.66717
R4970 vss_1v2.n3552 vss_1v2.n3551 5.66717
R4971 vss_1v2.n12 vss_1v2.n934 5.66717
R4972 vss_1v2.n3837 vss_1v2.n1897 5.66717
R4973 vss_1v2.n2450 vss_1v2.n2449 5.66717
R4974 vss_1v2.n2285 vss_1v2.n2096 5.66717
R4975 vss_1v2.n2451 vss_1v2.n2357 5.66717
R4976 vss_1v2.n3833 vss_1v2.n3831 5.66717
R4977 vss_1v2.n3830 vss_1v2.n2452 5.66717
R4978 vss_1v2.n2510 vss_1v2.n2509 5.66717
R4979 vss_1v2.n2508 vss_1v2.n2453 5.66717
R4980 vss_1v2.n2507 vss_1v2.n2506 5.66717
R4981 vss_1v2.n2454 vss_1v2.n1895 5.66717
R4982 vss_1v2.n2505 vss_1v2.n1904 5.66717
R4983 vss_1v2.n2455 vss_1v2.n1894 5.66717
R4984 vss_1v2.n2504 vss_1v2.n1905 5.66717
R4985 vss_1v2.n2456 vss_1v2.n1893 5.66717
R4986 vss_1v2.n3840 vss_1v2.n3839 5.66717
R4987 vss_1v2.n2913 vss_1v2.n2457 5.66717
R4988 vss_1v2.n2915 vss_1v2.n2503 5.66717
R4989 vss_1v2.n2917 vss_1v2.n2458 5.66717
R4990 vss_1v2.n2919 vss_1v2.n2502 5.66717
R4991 vss_1v2.n2920 vss_1v2.n2459 5.66717
R4992 vss_1v2.n2922 vss_1v2.n2501 5.66717
R4993 vss_1v2.t62 vss_1v2.n2460 5.66717
R4994 vss_1v2.n2924 vss_1v2.n2500 5.66717
R4995 vss_1v2.n2926 vss_1v2.n2500 5.66717
R4996 vss_1v2.n2928 vss_1v2.n2499 5.66717
R4997 vss_1v2.n3365 vss_1v2.n2461 5.66717
R4998 vss_1v2.n2956 vss_1v2.n418 5.66717
R4999 vss_1v2.n3817 vss_1v2.n2096 5.66717
R5000 vss_1v2.n3816 vss_1v2.n3815 5.66717
R5001 vss_1v2.n3814 vss_1v2.n2355 5.66717
R5002 vss_1v2.n3813 vss_1v2.n2097 5.66717
R5003 vss_1v2.n3812 vss_1v2.n2094 5.66717
R5004 vss_1v2.n3811 vss_1v2.n2098 5.66717
R5005 vss_1v2.n371 vss_1v2.n459 5.66717
R5006 vss_1v2.n371 vss_1v2.n460 5.66717
R5007 vss_1v2.n371 vss_1v2.n378 5.66717
R5008 vss_1v2.n3358 vss_1v2.n2099 5.66717
R5009 vss_1v2.n3362 vss_1v2.n3361 5.66717
R5010 vss_1v2.n3357 vss_1v2.n2363 5.66717
R5011 vss_1v2.n3353 vss_1v2.n2093 5.66717
R5012 vss_1v2.n3372 vss_1v2.n2101 5.66717
R5013 vss_1v2.n367 vss_1v2.n368 5.66717
R5014 vss_1v2.n367 vss_1v2.n461 5.66717
R5015 vss_1v2.n367 vss_1v2.n463 5.66717
R5016 vss_1v2.n481 vss_1v2.n480 5.66717
R5017 vss_1v2.n374 vss_1v2.n482 5.66717
R5018 vss_1v2.n375 vss_1v2.n469 5.66717
R5019 vss_1v2.n375 vss_1v2.n471 5.66717
R5020 vss_1v2.n437 vss_1v2.n3374 5.66717
R5021 vss_1v2.n473 vss_1v2.n472 5.66717
R5022 vss_1v2.n3376 vss_1v2.n2102 5.66717
R5023 vss_1v2.n3379 vss_1v2.n2091 5.66717
R5024 vss_1v2.n3348 vss_1v2.n2103 5.66717
R5025 vss_1v2.n3383 vss_1v2.n2090 5.66717
R5026 vss_1v2.n3386 vss_1v2.n2104 5.66717
R5027 vss_1v2.n423 vss_1v2.n2089 5.66717
R5028 vss_1v2.n424 vss_1v2.n466 5.66717
R5029 vss_1v2.n467 vss_1v2.n3388 5.66717
R5030 vss_1v2.n3389 vss_1v2.n2369 5.66717
R5031 vss_1v2.n3390 vss_1v2.n2088 5.66717
R5032 vss_1v2.n3391 vss_1v2.n2106 5.66717
R5033 vss_1v2.n2960 vss_1v2.n2087 5.66717
R5034 vss_1v2.n2966 vss_1v2.n2107 5.66717
R5035 vss_1v2.n2969 vss_1v2.n2086 5.66717
R5036 vss_1v2.n2972 vss_1v2.n2108 5.66717
R5037 vss_1v2.n2964 vss_1v2.n2085 5.66717
R5038 vss_1v2.n2961 vss_1v2.n2109 5.66717
R5039 vss_1v2.n2908 vss_1v2.n2084 5.66717
R5040 vss_1v2.n2911 vss_1v2.n2910 5.66717
R5041 vss_1v2.n2907 vss_1v2.n2342 5.66717
R5042 vss_1v2.n373 vss_1v2.n474 5.66717
R5043 vss_1v2.n373 vss_1v2.n475 5.66717
R5044 vss_1v2.n373 vss_1v2.n476 5.66717
R5045 vss_1v2.n478 vss_1v2.n477 5.66717
R5046 vss_1v2.n3429 vss_1v2.n2110 5.66717
R5047 vss_1v2.n3431 vss_1v2.n2082 5.66717
R5048 vss_1v2.n3400 vss_1v2.n2111 5.66717
R5049 vss_1v2.n3398 vss_1v2.n3397 5.66717
R5050 vss_1v2.t349 vss_1v2.n2375 5.66717
R5051 vss_1v2.n2876 vss_1v2.n2081 5.66717
R5052 vss_1v2.n2871 vss_1v2.n2113 5.66717
R5053 vss_1v2.n376 vss_1v2.n2080 5.66717
R5054 vss_1v2.n377 vss_1v2.n451 5.66717
R5055 vss_1v2.n377 vss_1v2.n453 5.66717
R5056 vss_1v2.n377 vss_1v2.n3452 5.66717
R5057 vss_1v2.n455 vss_1v2.n454 5.66717
R5058 vss_1v2.n3441 vss_1v2.n2114 5.66717
R5059 vss_1v2.n3444 vss_1v2.n2078 5.66717
R5060 vss_1v2.n3447 vss_1v2.n2115 5.66717
R5061 vss_1v2.n3438 vss_1v2.n2077 5.66717
R5062 vss_1v2.n3435 vss_1v2.n2116 5.66717
R5063 vss_1v2.n2118 vss_1v2.n2076 5.66717
R5064 vss_1v2.n2121 vss_1v2.n2120 5.66717
R5065 vss_1v2.n3461 vss_1v2.n2075 5.66717
R5066 vss_1v2.n3460 vss_1v2.n2122 5.66717
R5067 vss_1v2.n3466 vss_1v2.n3465 5.66717
R5068 vss_1v2.n3469 vss_1v2.n2382 5.66717
R5069 vss_1v2.n3457 vss_1v2.n2074 5.66717
R5070 vss_1v2.n2948 vss_1v2.n2124 5.66717
R5071 vss_1v2.n3474 vss_1v2.n2073 5.66717
R5072 vss_1v2.n3477 vss_1v2.n2125 5.66717
R5073 vss_1v2.n2946 vss_1v2.n2072 5.66717
R5074 vss_1v2.n2944 vss_1v2.n2126 5.66717
R5075 vss_1v2.n4018 vss_1v2.n4017 5.66717
R5076 vss_1v2.n3808 vss_1v2.n418 5.66717
R5077 vss_1v2.n3806 vss_1v2.n418 5.66717
R5078 vss_1v2.n3804 vss_1v2.n418 5.66717
R5079 vss_1v2.n3802 vss_1v2.n418 5.66717
R5080 vss_1v2.n3800 vss_1v2.n418 5.66717
R5081 vss_1v2.n3798 vss_1v2.n418 5.66717
R5082 vss_1v2.n3796 vss_1v2.n418 5.66717
R5083 vss_1v2.n3794 vss_1v2.n418 5.66717
R5084 vss_1v2.n3792 vss_1v2.n418 5.66717
R5085 vss_1v2.n3790 vss_1v2.n418 5.66717
R5086 vss_1v2.n3788 vss_1v2.n418 5.66717
R5087 vss_1v2.n3786 vss_1v2.n418 5.66717
R5088 vss_1v2.n3784 vss_1v2.n418 5.66717
R5089 vss_1v2.n3782 vss_1v2.n418 5.66717
R5090 vss_1v2.n2533 vss_1v2.n418 5.66717
R5091 vss_1v2.n2536 vss_1v2.n418 5.66717
R5092 vss_1v2.n3774 vss_1v2.n418 5.66717
R5093 vss_1v2.n3772 vss_1v2.n418 5.66717
R5094 vss_1v2.n3769 vss_1v2.n418 5.66717
R5095 vss_1v2.n2542 vss_1v2.n418 5.66717
R5096 vss_1v2.n2544 vss_1v2.n418 5.66717
R5097 vss_1v2.n2547 vss_1v2.n418 5.66717
R5098 vss_1v2.n444 vss_1v2.n418 2.83186
R5099 vss_1v2.n447 vss_1v2.n444 0.00594278
R5100 vss_1v2.n445 vss_1v2.n418 5.66717
R5101 vss_1v2.n2554 vss_1v2.n418 5.66717
R5102 vss_1v2.n2557 vss_1v2.n418 5.66717
R5103 vss_1v2.n2559 vss_1v2.n418 5.66717
R5104 vss_1v2.n3748 vss_1v2.n418 5.66717
R5105 vss_1v2.n448 vss_1v2.n418 2.83186
R5106 vss_1v2.n449 vss_1v2.n448 0.00594278
R5107 vss_1v2.n2565 vss_1v2.n418 5.66717
R5108 vss_1v2.n2568 vss_1v2.n418 5.66717
R5109 vss_1v2.n3736 vss_1v2.n418 5.66717
R5110 vss_1v2.n3734 vss_1v2.n418 5.66717
R5111 vss_1v2.n3731 vss_1v2.n418 5.66717
R5112 vss_1v2.n2569 vss_1v2.n418 5.66717
R5113 vss_1v2.n2575 vss_1v2.n418 5.66717
R5114 vss_1v2.n2577 vss_1v2.n418 5.66717
R5115 vss_1v2.n426 vss_1v2.n418 2.83186
R5116 vss_1v2.n429 vss_1v2.n426 0.00594278
R5117 vss_1v2.n427 vss_1v2.n418 5.66717
R5118 vss_1v2.n2584 vss_1v2.n418 5.66717
R5119 vss_1v2.n2587 vss_1v2.n418 5.66717
R5120 vss_1v2.n2589 vss_1v2.n418 5.66717
R5121 vss_1v2.n3710 vss_1v2.n418 5.66717
R5122 vss_1v2.n3707 vss_1v2.n418 5.66717
R5123 vss_1v2.n2590 vss_1v2.n418 5.66717
R5124 vss_1v2.n2597 vss_1v2.n418 5.66717
R5125 vss_1v2.n2600 vss_1v2.n418 5.66717
R5126 vss_1v2.n3695 vss_1v2.n418 5.66717
R5127 vss_1v2.n3693 vss_1v2.n418 5.66717
R5128 vss_1v2.n3690 vss_1v2.n418 5.66717
R5129 vss_1v2.n2606 vss_1v2.n418 5.66717
R5130 vss_1v2.n2609 vss_1v2.n418 5.66717
R5131 vss_1v2.n2611 vss_1v2.n418 5.66717
R5132 vss_1v2.n419 vss_1v2.n418 2.83186
R5133 vss_1v2.n422 vss_1v2.n419 0.00594278
R5134 vss_1v2.n420 vss_1v2.n418 5.66717
R5135 vss_1v2.n2618 vss_1v2.n418 5.66717
R5136 vss_1v2.n2621 vss_1v2.n418 5.66717
R5137 vss_1v2.n3671 vss_1v2.n418 5.66717
R5138 vss_1v2.n3669 vss_1v2.n418 5.66717
R5139 vss_1v2.n430 vss_1v2.n418 2.83186
R5140 vss_1v2.n431 vss_1v2.n430 0.00594278
R5141 vss_1v2.n2628 vss_1v2.n418 5.66717
R5142 vss_1v2.n2631 vss_1v2.n418 5.66717
R5143 vss_1v2.n3657 vss_1v2.n418 5.66717
R5144 vss_1v2.n3655 vss_1v2.n418 5.66717
R5145 vss_1v2.n3652 vss_1v2.n418 5.66717
R5146 vss_1v2.n2638 vss_1v2.n418 5.66717
R5147 vss_1v2.n2641 vss_1v2.n418 5.66717
R5148 vss_1v2.n2643 vss_1v2.n418 5.66717
R5149 vss_1v2.n3641 vss_1v2.n418 5.66717
R5150 vss_1v2.n2803 vss_1v2.n418 5.66717
R5151 vss_1v2.n2799 vss_1v2.n418 5.66717
R5152 vss_1v2.n2796 vss_1v2.n418 5.66717
R5153 vss_1v2.n2793 vss_1v2.n418 5.66717
R5154 vss_1v2.n2790 vss_1v2.n418 5.66717
R5155 vss_1v2.n2787 vss_1v2.n418 5.66717
R5156 vss_1v2.n2784 vss_1v2.n418 5.66717
R5157 vss_1v2.n2781 vss_1v2.n418 5.66717
R5158 vss_1v2.n2778 vss_1v2.n418 5.66717
R5159 vss_1v2.n2775 vss_1v2.n418 5.66717
R5160 vss_1v2.n2772 vss_1v2.n418 5.66717
R5161 vss_1v2.n2769 vss_1v2.n418 5.66717
R5162 vss_1v2.n2766 vss_1v2.n418 5.66717
R5163 vss_1v2.n2698 vss_1v2.n418 5.66717
R5164 vss_1v2.n2763 vss_1v2.n418 5.66717
R5165 vss_1v2.n2760 vss_1v2.n418 5.66717
R5166 vss_1v2.n2757 vss_1v2.n418 5.66717
R5167 vss_1v2.n2754 vss_1v2.n418 5.66717
R5168 vss_1v2.n2751 vss_1v2.n418 5.66717
R5169 vss_1v2.n2748 vss_1v2.n418 5.66717
R5170 vss_1v2.n2745 vss_1v2.n418 5.66717
R5171 vss_1v2.n2742 vss_1v2.n418 5.66717
R5172 vss_1v2.n2739 vss_1v2.n418 5.66717
R5173 vss_1v2.n2736 vss_1v2.n418 5.66717
R5174 vss_1v2.n2733 vss_1v2.n418 5.66717
R5175 vss_1v2.n2730 vss_1v2.n418 5.66717
R5176 vss_1v2.n2727 vss_1v2.n418 5.66717
R5177 vss_1v2.n2724 vss_1v2.n418 5.66717
R5178 vss_1v2.n2721 vss_1v2.n418 5.66717
R5179 vss_1v2.n2718 vss_1v2.n418 5.66717
R5180 vss_1v2.n2715 vss_1v2.n418 5.66717
R5181 vss_1v2.n2712 vss_1v2.n418 5.66717
R5182 vss_1v2.n2709 vss_1v2.n418 5.66717
R5183 vss_1v2.n2706 vss_1v2.n418 5.66717
R5184 vss_1v2.n2703 vss_1v2.n418 5.66717
R5185 vss_1v2.n2700 vss_1v2.n418 5.66717
R5186 vss_1v2.n418 vss_1v2.n2462 5.66717
R5187 vss_1v2.n418 vss_1v2.n2463 5.66717
R5188 vss_1v2.n418 vss_1v2.n2464 5.66717
R5189 vss_1v2.n418 vss_1v2.n2465 5.66717
R5190 vss_1v2.n418 vss_1v2.n2466 5.66717
R5191 vss_1v2.n418 vss_1v2.n2467 5.66717
R5192 vss_1v2.n418 vss_1v2.n2468 5.66717
R5193 vss_1v2.n418 vss_1v2.n2469 5.66717
R5194 vss_1v2.n418 vss_1v2.n2470 5.66717
R5195 vss_1v2.n418 vss_1v2.n2471 5.66717
R5196 vss_1v2.n418 vss_1v2.n2472 5.66717
R5197 vss_1v2.n418 vss_1v2.n2473 5.66717
R5198 vss_1v2.n418 vss_1v2.n2474 5.66717
R5199 vss_1v2.n418 vss_1v2.n2475 5.66717
R5200 vss_1v2.n418 vss_1v2.n2476 5.66717
R5201 vss_1v2.n418 vss_1v2.n2477 5.66717
R5202 vss_1v2.n418 vss_1v2.n2478 5.66717
R5203 vss_1v2.n418 vss_1v2.n2479 5.66717
R5204 vss_1v2.n418 vss_1v2.n2480 5.66717
R5205 vss_1v2.n418 vss_1v2.n2481 5.66717
R5206 vss_1v2.n418 vss_1v2.n2482 5.66717
R5207 vss_1v2.n418 vss_1v2.n2483 5.66717
R5208 vss_1v2.n418 vss_1v2.n2484 5.66717
R5209 vss_1v2.n418 vss_1v2.n2485 5.66717
R5210 vss_1v2.n418 vss_1v2.n2486 5.66717
R5211 vss_1v2.n418 vss_1v2.n2487 5.66717
R5212 vss_1v2.n418 vss_1v2.n2488 5.66717
R5213 vss_1v2.n418 vss_1v2.n2489 5.66717
R5214 vss_1v2.n418 vss_1v2.n2490 5.66717
R5215 vss_1v2.n418 vss_1v2.n2491 5.66717
R5216 vss_1v2.n418 vss_1v2.n2492 5.66717
R5217 vss_1v2.n418 vss_1v2.n2493 5.66717
R5218 vss_1v2.n418 vss_1v2.n2494 5.66717
R5219 vss_1v2.n418 vss_1v2.n2495 5.66717
R5220 vss_1v2.n418 vss_1v2.n2496 5.66717
R5221 vss_1v2.n418 vss_1v2.n2497 5.66717
R5222 vss_1v2.n418 vss_1v2.n2498 5.66717
R5223 vss_1v2.n2692 vss_1v2.n418 5.66717
R5224 vss_1v2.n12 vss_1v2.n728 5.66717
R5225 vss_1v2.n12 vss_1v2.n726 5.66717
R5226 vss_1v2.n12 vss_1v2.n709 5.66717
R5227 vss_1v2.n12 vss_1v2.n724 5.66717
R5228 vss_1v2.n12 vss_1v2.n710 5.66717
R5229 vss_1v2.n12 vss_1v2.n723 5.66717
R5230 vss_1v2.n12 vss_1v2.n711 5.66717
R5231 vss_1v2.n12 vss_1v2.n722 5.66717
R5232 vss_1v2.n12 vss_1v2.n712 5.66717
R5233 vss_1v2.n12 vss_1v2.n721 5.66717
R5234 vss_1v2.n12 vss_1v2.n715 5.66717
R5235 vss_1v2.n12 vss_1v2.n727 5.66717
R5236 vss_1v2.n12 vss_1v2.n703 5.66717
R5237 vss_1v2.n4129 vss_1v2.n1876 5.66717
R5238 vss_1v2.n4129 vss_1v2.n1841 5.66717
R5239 vss_1v2.n4129 vss_1v2.n1875 5.66717
R5240 vss_1v2.n4129 vss_1v2.n364 2.83376
R5241 vss_1v2.n365 vss_1v2.n4129 5.66717
R5242 vss_1v2.n4129 vss_1v2.n1874 5.66717
R5243 vss_1v2.n4129 vss_1v2.n1842 5.66717
R5244 vss_1v2.n4129 vss_1v2.n1873 5.66717
R5245 vss_1v2.n4129 vss_1v2.n1843 5.66717
R5246 vss_1v2.n4129 vss_1v2.n1872 5.66717
R5247 vss_1v2.n4129 vss_1v2.n361 2.83359
R5248 vss_1v2.n4129 vss_1v2.n362 5.66717
R5249 vss_1v2.n4129 vss_1v2.n1871 5.66717
R5250 vss_1v2.n4129 vss_1v2.n1844 5.66717
R5251 vss_1v2.n4129 vss_1v2.n1870 5.66717
R5252 vss_1v2.n4129 vss_1v2.n39 5.66717
R5253 vss_1v2.n4129 vss_1v2.n40 1.41586
R5254 vss_1v2.n40 vss_1v2.n356 0.00415139
R5255 vss_1v2.n4129 vss_1v2.n443 2.83331
R5256 vss_1v2.n443 vss_1v2.n442 0.00305001
R5257 vss_1v2.n4129 vss_1v2.n355 1.13341
R5258 vss_1v2.n4129 vss_1v2.n354 5.66717
R5259 vss_1v2.n4129 vss_1v2.n1868 5.66717
R5260 vss_1v2.n4129 vss_1v2.n1845 5.66717
R5261 vss_1v2.n4129 vss_1v2.n1867 5.66717
R5262 vss_1v2.n4129 vss_1v2.n359 5.66717
R5263 vss_1v2.n4129 vss_1v2.n358 2.83356
R5264 vss_1v2.n4129 vss_1v2.n1866 5.66717
R5265 vss_1v2.n4129 vss_1v2.n1846 5.66717
R5266 vss_1v2.n4129 vss_1v2.n1865 5.66717
R5267 vss_1v2.n4129 vss_1v2.n1847 5.66717
R5268 vss_1v2.n4129 vss_1v2.n1864 5.66717
R5269 vss_1v2.n4129 vss_1v2.n488 5.66717
R5270 vss_1v2.n4129 vss_1v2.n388 2.83383
R5271 vss_1v2.n4129 vss_1v2.n1863 5.66717
R5272 vss_1v2.n4129 vss_1v2.n1848 5.66717
R5273 vss_1v2.n4129 vss_1v2.n1862 5.66717
R5274 vss_1v2.n4129 vss_1v2.n1849 5.66717
R5275 vss_1v2.n4129 vss_1v2.n1861 5.66717
R5276 vss_1v2.n4129 vss_1v2.n1850 5.66717
R5277 vss_1v2.n4129 vss_1v2.n1860 5.66717
R5278 vss_1v2.n4129 vss_1v2.n1851 5.66717
R5279 vss_1v2.n4129 vss_1v2.n1859 5.66717
R5280 vss_1v2.n4129 vss_1v2.n1852 5.66717
R5281 vss_1v2.n4129 vss_1v2.n1858 5.66717
R5282 vss_1v2.n4129 vss_1v2.n712 5.66717
R5283 vss_1v2.n4129 vss_1v2.n722 5.66717
R5284 vss_1v2.n4129 vss_1v2.n710 5.66717
R5285 vss_1v2.n4129 vss_1v2.n724 5.66717
R5286 vss_1v2.n4129 vss_1v2.n709 5.66717
R5287 vss_1v2.n4129 vss_1v2.n1910 5.66717
R5288 vss_1v2.n4129 vss_1v2.n1893 5.66717
R5289 vss_1v2.n4129 vss_1v2.n1905 5.66717
R5290 vss_1v2.n4129 vss_1v2.n1894 5.66717
R5291 vss_1v2.n4129 vss_1v2.n1904 5.66717
R5292 vss_1v2.n4129 vss_1v2.n1895 5.66717
R5293 vss_1v2.n4129 vss_1v2.n1897 5.66717
R5294 vss_1v2.n3845 vss_1v2.n3844 5.66717
R5295 vss_1v2.n3846 vss_1v2.n2333 5.66717
R5296 vss_1v2.n3847 vss_1v2.n2128 5.66717
R5297 vss_1v2.n3849 vss_1v2.n3848 5.66717
R5298 vss_1v2.n3850 vss_1v2.n2385 5.66717
R5299 vss_1v2.n3851 vss_1v2.n2070 5.66717
R5300 vss_1v2.n3852 vss_1v2.n2129 5.66717
R5301 vss_1v2.n3853 vss_1v2.n2069 5.66717
R5302 vss_1v2.n3854 vss_1v2.n2130 5.66717
R5303 vss_1v2.n3855 vss_1v2.n2068 5.66717
R5304 vss_1v2.n3857 vss_1v2.n3856 5.66717
R5305 vss_1v2.n3858 vss_1v2.n2328 5.66717
R5306 vss_1v2.n3859 vss_1v2.n2132 5.66717
R5307 vss_1v2.n3860 vss_1v2.n2067 5.66717
R5308 vss_1v2.n3861 vss_1v2.n2133 5.66717
R5309 vss_1v2.n3862 vss_1v2.n2066 5.66717
R5310 vss_1v2.n3863 vss_1v2.n2134 5.66717
R5311 vss_1v2.n3864 vss_1v2.n2065 5.66717
R5312 vss_1v2.n3865 vss_1v2.n2135 5.66717
R5313 vss_1v2.n3866 vss_1v2.n2064 5.66717
R5314 vss_1v2.n3867 vss_1v2.n2136 5.66717
R5315 vss_1v2.n3868 vss_1v2.n2063 5.66717
R5316 vss_1v2.n3869 vss_1v2.n2137 5.66717
R5317 vss_1v2.n3870 vss_1v2.n2062 5.66717
R5318 vss_1v2.n3871 vss_1v2.n2138 5.66717
R5319 vss_1v2.n3872 vss_1v2.n2061 5.66717
R5320 vss_1v2.n3873 vss_1v2.n2139 5.66717
R5321 vss_1v2.n3874 vss_1v2.n2060 5.66717
R5322 vss_1v2.n3875 vss_1v2.n2140 5.66717
R5323 vss_1v2.n3876 vss_1v2.n2059 5.66717
R5324 vss_1v2.n3877 vss_1v2.n2141 5.66717
R5325 vss_1v2.n3878 vss_1v2.n2058 5.66717
R5326 vss_1v2.n3879 vss_1v2.n2142 5.66717
R5327 vss_1v2.n3880 vss_1v2.n2057 5.66717
R5328 vss_1v2.n3881 vss_1v2.n2143 5.66717
R5329 vss_1v2.n3882 vss_1v2.n2056 5.66717
R5330 vss_1v2.n3883 vss_1v2.n2144 5.66717
R5331 vss_1v2.n3885 vss_1v2.n3884 5.66717
R5332 vss_1v2.n3886 vss_1v2.n2400 5.66717
R5333 vss_1v2.n3887 vss_1v2.n2055 5.66717
R5334 vss_1v2.n3888 vss_1v2.n2146 5.66717
R5335 vss_1v2.n3889 vss_1v2.n2054 5.66717
R5336 vss_1v2.n3891 vss_1v2.n3890 5.66717
R5337 vss_1v2.n3892 vss_1v2.n2324 5.66717
R5338 vss_1v2.n3893 vss_1v2.n2147 5.66717
R5339 vss_1v2.n3895 vss_1v2.n3894 5.66717
R5340 vss_1v2.n3896 vss_1v2.n2403 5.66717
R5341 vss_1v2.n3897 vss_1v2.n2052 5.66717
R5342 vss_1v2.n3898 vss_1v2.n2149 5.66717
R5343 vss_1v2.n3899 vss_1v2.n2051 5.66717
R5344 vss_1v2.n3900 vss_1v2.n2150 5.66717
R5345 vss_1v2.n3901 vss_1v2.n2320 5.66717
R5346 vss_1v2.n3903 vss_1v2.n3902 5.66717
R5347 vss_1v2.n3904 vss_1v2.n2050 5.66717
R5348 vss_1v2.n3905 vss_1v2.n2152 5.66717
R5349 vss_1v2.n3907 vss_1v2.n3906 5.66717
R5350 vss_1v2.n3908 vss_1v2.n2407 5.66717
R5351 vss_1v2.n3909 vss_1v2.n2049 5.66717
R5352 vss_1v2.n3910 vss_1v2.n2154 5.66717
R5353 vss_1v2.n3911 vss_1v2.n2048 5.66717
R5354 vss_1v2.n3912 vss_1v2.n2155 5.66717
R5355 vss_1v2.n3913 vss_1v2.n2047 5.66717
R5356 vss_1v2.n3914 vss_1v2.n2156 5.66717
R5357 vss_1v2.n3915 vss_1v2.n2046 5.66717
R5358 vss_1v2.n3916 vss_1v2.n2157 5.66717
R5359 vss_1v2.n3917 vss_1v2.n2045 5.66717
R5360 vss_1v2.n3919 vss_1v2.n3918 5.66717
R5361 vss_1v2.n3920 vss_1v2.n2313 5.66717
R5362 vss_1v2.n3921 vss_1v2.n2158 5.66717
R5363 vss_1v2.n3922 vss_1v2.n2043 5.66717
R5364 vss_1v2.n3923 vss_1v2.n2159 5.66717
R5365 vss_1v2.n3924 vss_1v2.n2042 5.66717
R5366 vss_1v2.n3925 vss_1v2.n2160 5.66717
R5367 vss_1v2.n3926 vss_1v2.n2041 5.66717
R5368 vss_1v2.n3927 vss_1v2.n2161 5.66717
R5369 vss_1v2.n3929 vss_1v2.n3928 5.66717
R5370 vss_1v2.n3930 vss_1v2.n2413 5.66717
R5371 vss_1v2.n3931 vss_1v2.n2040 5.66717
R5372 vss_1v2.n3932 vss_1v2.n2163 5.66717
R5373 vss_1v2.n3933 vss_1v2.n2039 5.66717
R5374 vss_1v2.n3934 vss_1v2.n2164 5.66717
R5375 vss_1v2.n3935 vss_1v2.n2038 5.66717
R5376 vss_1v2.n3936 vss_1v2.n2165 5.66717
R5377 vss_1v2.n3937 vss_1v2.n2037 5.66717
R5378 vss_1v2.n3938 vss_1v2.n2166 5.66717
R5379 vss_1v2.n3939 vss_1v2.n2036 5.66717
R5380 vss_1v2.n3941 vss_1v2.n3940 5.66717
R5381 vss_1v2.n3942 vss_1v2.n2306 5.66717
R5382 vss_1v2.n3943 vss_1v2.n2167 5.66717
R5383 vss_1v2.n3944 vss_1v2.n2034 5.66717
R5384 vss_1v2.n3945 vss_1v2.n2168 5.66717
R5385 vss_1v2.n3946 vss_1v2.n2033 5.66717
R5386 vss_1v2.n3947 vss_1v2.n2169 5.66717
R5387 vss_1v2.n3948 vss_1v2.n2032 5.66717
R5388 vss_1v2.n3949 vss_1v2.n2170 5.66717
R5389 vss_1v2.n3951 vss_1v2.n3950 5.66717
R5390 vss_1v2.n3952 vss_1v2.n2419 5.66717
R5391 vss_1v2.n3953 vss_1v2.n2031 5.66717
R5392 vss_1v2.n3954 vss_1v2.n2172 5.66717
R5393 vss_1v2.n3955 vss_1v2.n2030 5.66717
R5394 vss_1v2.n3956 vss_1v2.n2173 5.66717
R5395 vss_1v2.n3957 vss_1v2.n2029 5.66717
R5396 vss_1v2.n3958 vss_1v2.n2174 5.66717
R5397 vss_1v2.n3959 vss_1v2.n2028 5.66717
R5398 vss_1v2.n3960 vss_1v2.n2175 5.66717
R5399 vss_1v2.n3961 vss_1v2.n2027 5.66717
R5400 vss_1v2.n3963 vss_1v2.n3962 5.66717
R5401 vss_1v2.n3964 vss_1v2.n2299 5.66717
R5402 vss_1v2.n3965 vss_1v2.n2176 5.66717
R5403 vss_1v2.n3966 vss_1v2.n2025 5.66717
R5404 vss_1v2.n3967 vss_1v2.n2177 5.66717
R5405 vss_1v2.n3968 vss_1v2.n2024 5.66717
R5406 vss_1v2.n3969 vss_1v2.n2178 5.66717
R5407 vss_1v2.n3970 vss_1v2.n2023 5.66717
R5408 vss_1v2.n3971 vss_1v2.n2179 5.66717
R5409 vss_1v2.n3972 vss_1v2.n2022 5.66717
R5410 vss_1v2.n3973 vss_1v2.n2180 5.66717
R5411 vss_1v2.n3975 vss_1v2.n3974 5.66717
R5412 vss_1v2.n3976 vss_1v2.n2426 5.66717
R5413 vss_1v2.n3977 vss_1v2.n2021 5.66717
R5414 vss_1v2.n3978 vss_1v2.n2182 5.66717
R5415 vss_1v2.n3979 vss_1v2.n2020 5.66717
R5416 vss_1v2.n3980 vss_1v2.n2183 5.66717
R5417 vss_1v2.n3981 vss_1v2.n2019 5.66717
R5418 vss_1v2.n3982 vss_1v2.n2184 5.66717
R5419 vss_1v2.n3983 vss_1v2.n2018 5.66717
R5420 vss_1v2.n3985 vss_1v2.n3984 5.66717
R5421 vss_1v2.n3986 vss_1v2.n2293 5.66717
R5422 vss_1v2.n3987 vss_1v2.n2185 5.66717
R5423 vss_1v2.n3988 vss_1v2.n2016 5.66717
R5424 vss_1v2.n3989 vss_1v2.n2186 5.66717
R5425 vss_1v2.n3990 vss_1v2.n2015 5.66717
R5426 vss_1v2.n3991 vss_1v2.n2187 5.66717
R5427 vss_1v2.n3992 vss_1v2.n2014 5.66717
R5428 vss_1v2.n3993 vss_1v2.n2188 5.66717
R5429 vss_1v2.n3994 vss_1v2.n2013 5.66717
R5430 vss_1v2.n3995 vss_1v2.n2189 5.66717
R5431 vss_1v2.n3997 vss_1v2.n3996 5.66717
R5432 vss_1v2.n3999 vss_1v2.n3998 5.66717
R5433 vss_1v2.n2441 vss_1v2.n2012 5.66717
R5434 vss_1v2.n2440 vss_1v2.n2191 5.66717
R5435 vss_1v2.n2439 vss_1v2.n2011 5.66717
R5436 vss_1v2.n2438 vss_1v2.n2192 5.66717
R5437 vss_1v2.n2437 vss_1v2.n2010 5.66717
R5438 vss_1v2.n2436 vss_1v2.n2193 5.66717
R5439 vss_1v2.n2435 vss_1v2.n2009 5.66717
R5440 vss_1v2.n2434 vss_1v2.n2194 5.66717
R5441 vss_1v2.n2433 vss_1v2.n2008 5.66717
R5442 vss_1v2.n2286 vss_1v2.n2283 5.66717
R5443 vss_1v2.n4005 vss_1v2.n4004 5.66717
R5444 vss_1v2.n4006 vss_1v2.n2195 5.66717
R5445 vss_1v2.n4007 vss_1v2.n2006 5.66717
R5446 vss_1v2.n4008 vss_1v2.n2196 5.66717
R5447 vss_1v2.n4009 vss_1v2.n2005 5.66717
R5448 vss_1v2.n4010 vss_1v2.n2197 5.66717
R5449 vss_1v2.n4011 vss_1v2.n2004 5.66717
R5450 vss_1v2.n4012 vss_1v2.n2198 5.66717
R5451 vss_1v2.n4014 vss_1v2.n4013 5.66717
R5452 vss_1v2.n2282 vss_1v2.n2199 5.66717
R5453 vss_1v2.n2281 vss_1v2.n2003 5.66717
R5454 vss_1v2.n3834 vss_1v2.n3833 5.66693
R5455 vss_1v2.n3537 vss_1v2.n2858 5.66672
R5456 vss_1v2.n4133 vss_1v2.n1270 5.66643
R5457 vss_1v2.n3311 vss_1v2.n462 5.66174
R5458 vss_1v2.n260 vss_1v2.n1298 5.65478
R5459 vss_1v2.n20 vss_1v2.n4081 2.09793
R5460 vss_1v2.n260 vss_1v2.n1297 5.51002
R5461 vss_1v2.n4133 vss_1v2.n1226 5.5099
R5462 vss_1v2.n1965 vss_1v2.n1296 5.5099
R5463 vss_1v2.n1965 vss_1v2.n1964 5.50783
R5464 vss_1v2.n3483 vss_1v2.n1968 5.50783
R5465 vss_1v2.n64 vss_1v2.n637 5.47027
R5466 vss_1v2.n58 vss_1v2.n794 5.47027
R5467 vss_1v2.n65 vss_1v2.n635 5.47027
R5468 vss_1v2.n57 vss_1v2.n795 5.47027
R5469 vss_1v2.n66 vss_1v2.n634 5.47027
R5470 vss_1v2.n56 vss_1v2.n797 5.47027
R5471 vss_1v2.n67 vss_1v2.n632 5.47027
R5472 vss_1v2.n55 vss_1v2.n799 5.47027
R5473 vss_1v2.n68 vss_1v2.n630 5.47027
R5474 vss_1v2.n54 vss_1v2.n801 5.47027
R5475 vss_1v2.n69 vss_1v2.n629 5.47027
R5476 vss_1v2.n53 vss_1v2.n802 5.47027
R5477 vss_1v2.n70 vss_1v2.n627 5.47027
R5478 vss_1v2.n149 vss_1v2.n804 5.47027
R5479 vss_1v2.n150 vss_1v2.n625 5.47027
R5480 vss_1v2.n151 vss_1v2.n806 5.47027
R5481 vss_1v2.n152 vss_1v2.n623 5.47027
R5482 vss_1v2.n153 vss_1v2.n808 5.47027
R5483 vss_1v2.n154 vss_1v2.n621 5.47027
R5484 vss_1v2.n155 vss_1v2.n810 5.47027
R5485 vss_1v2.n156 vss_1v2.n619 5.47027
R5486 vss_1v2.n157 vss_1v2.n812 5.47027
R5487 vss_1v2.n158 vss_1v2.n617 5.47027
R5488 vss_1v2.n159 vss_1v2.n814 5.47027
R5489 vss_1v2.n160 vss_1v2.n615 5.47027
R5490 vss_1v2.n161 vss_1v2.n816 5.47027
R5491 vss_1v2.n162 vss_1v2.n613 5.47027
R5492 vss_1v2.n163 vss_1v2.n817 5.47027
R5493 vss_1v2.n165 vss_1v2.n819 5.47027
R5494 vss_1v2.n166 vss_1v2.n610 5.47027
R5495 vss_1v2.n167 vss_1v2.n821 5.47027
R5496 vss_1v2.n169 vss_1v2.n823 5.47027
R5497 vss_1v2.n170 vss_1v2.n607 5.47027
R5498 vss_1v2.n171 vss_1v2.n824 5.47027
R5499 vss_1v2.n173 vss_1v2.n826 5.47027
R5500 vss_1v2.n174 vss_1v2.n603 5.47027
R5501 vss_1v2.n175 vss_1v2.n828 5.47027
R5502 vss_1v2.n177 vss_1v2.n830 5.47027
R5503 vss_1v2.n178 vss_1v2.n599 5.47027
R5504 vss_1v2.n179 vss_1v2.n832 5.47027
R5505 vss_1v2.n180 vss_1v2.n597 5.47027
R5506 vss_1v2.n182 vss_1v2.n595 5.47027
R5507 vss_1v2.n183 vss_1v2.n836 5.47027
R5508 vss_1v2.n184 vss_1v2.n593 5.47027
R5509 vss_1v2.n185 vss_1v2.n838 5.47027
R5510 vss_1v2.n186 vss_1v2.n591 5.47027
R5511 vss_1v2.n187 vss_1v2.n839 5.47027
R5512 vss_1v2.n188 vss_1v2.n590 5.47027
R5513 vss_1v2.n189 vss_1v2.n841 5.47027
R5514 vss_1v2.n190 vss_1v2.n588 5.47027
R5515 vss_1v2.n192 vss_1v2.n586 5.47027
R5516 vss_1v2.n193 vss_1v2.n845 5.47027
R5517 vss_1v2.n194 vss_1v2.n585 5.47027
R5518 vss_1v2.n196 vss_1v2.n583 5.47027
R5519 vss_1v2.n197 vss_1v2.n848 5.47027
R5520 vss_1v2.n200 vss_1v2.n579 5.47027
R5521 vss_1v2.n202 vss_1v2.n577 5.47027
R5522 vss_1v2.n8 vss_1v2.n12 6.59124
R5523 vss_1v2.n205 vss_1v2.n856 5.47027
R5524 vss_1v2.n248 vss_1v2.t266 5.3559
R5525 vss_1v2.n18 vss_1v2.n3200 5.31398
R5526 vss_1v2.n3553 vss_1v2.n3552 5.18142
R5527 vss_1v2.t5 vss_1v2.n288 5.18142
R5528 vss_1v2.n238 vss_1v2.t19 5.11248
R5529 vss_1v2.n2927 vss_1v2.n2926 5.05807
R5530 vss_1v2.n2926 vss_1v2.t55 5.05807
R5531 vss_1v2.n2922 vss_1v2.t63 5.05807
R5532 vss_1v2.n86 vss_1v2.n729 5.02376
R5533 vss_1v2.n87 vss_1v2.n699 5.02376
R5534 vss_1v2.n88 vss_1v2.n731 5.02376
R5535 vss_1v2.n89 vss_1v2.n697 5.02376
R5536 vss_1v2.n90 vss_1v2.n733 5.02376
R5537 vss_1v2.n91 vss_1v2.n695 5.02376
R5538 vss_1v2.n92 vss_1v2.n735 5.02376
R5539 vss_1v2.n93 vss_1v2.n693 5.02376
R5540 vss_1v2.n94 vss_1v2.n737 5.02376
R5541 vss_1v2.n95 vss_1v2.n691 5.02376
R5542 vss_1v2.n96 vss_1v2.n739 5.02376
R5543 vss_1v2.n97 vss_1v2.n689 5.02376
R5544 vss_1v2.n98 vss_1v2.n741 5.02376
R5545 vss_1v2.n99 vss_1v2.n687 5.02376
R5546 vss_1v2.n100 vss_1v2.n742 5.02376
R5547 vss_1v2.n101 vss_1v2.n686 5.02376
R5548 vss_1v2.n102 vss_1v2.n744 5.02376
R5549 vss_1v2.n103 vss_1v2.n684 5.02376
R5550 vss_1v2.n104 vss_1v2.n746 5.02376
R5551 vss_1v2.n105 vss_1v2.n682 5.02376
R5552 vss_1v2.n106 vss_1v2.n748 5.02376
R5553 vss_1v2.n107 vss_1v2.n680 5.02376
R5554 vss_1v2.n109 vss_1v2.n678 5.02376
R5555 vss_1v2.n110 vss_1v2.n752 5.02376
R5556 vss_1v2.n111 vss_1v2.n676 5.02376
R5557 vss_1v2.n112 vss_1v2.n754 5.02376
R5558 vss_1v2.n113 vss_1v2.n674 5.02376
R5559 vss_1v2.n114 vss_1v2.n756 5.02376
R5560 vss_1v2.n115 vss_1v2.n672 5.02376
R5561 vss_1v2.n116 vss_1v2.n758 5.02376
R5562 vss_1v2.n117 vss_1v2.n671 5.02376
R5563 vss_1v2.n118 vss_1v2.n759 5.02376
R5564 vss_1v2.n119 vss_1v2.n669 5.02376
R5565 vss_1v2.n120 vss_1v2.n761 5.02376
R5566 vss_1v2.n121 vss_1v2.n667 5.02376
R5567 vss_1v2.n122 vss_1v2.n763 5.02376
R5568 vss_1v2.n123 vss_1v2.n665 5.02376
R5569 vss_1v2.n124 vss_1v2.n764 5.02376
R5570 vss_1v2.n125 vss_1v2.n664 5.02376
R5571 vss_1v2.n126 vss_1v2.n766 5.02376
R5572 vss_1v2.n127 vss_1v2.n662 5.02376
R5573 vss_1v2.n128 vss_1v2.n768 5.02376
R5574 vss_1v2.n129 vss_1v2.n660 5.02376
R5575 vss_1v2.n130 vss_1v2.n770 5.02376
R5576 vss_1v2.n131 vss_1v2.n658 5.02376
R5577 vss_1v2.n132 vss_1v2.n772 5.02376
R5578 vss_1v2.n133 vss_1v2.n656 5.02376
R5579 vss_1v2.n134 vss_1v2.n774 5.02376
R5580 vss_1v2.n135 vss_1v2.n654 5.02376
R5581 vss_1v2.n136 vss_1v2.n776 5.02376
R5582 vss_1v2.n137 vss_1v2.n652 5.02376
R5583 vss_1v2.n138 vss_1v2.n778 5.02376
R5584 vss_1v2.n140 vss_1v2.n780 5.02376
R5585 vss_1v2.n141 vss_1v2.n649 5.02376
R5586 vss_1v2.n142 vss_1v2.n781 5.02376
R5587 vss_1v2.n143 vss_1v2.n647 5.02376
R5588 vss_1v2.n144 vss_1v2.n783 5.02376
R5589 vss_1v2.n145 vss_1v2.n645 5.02376
R5590 vss_1v2.n146 vss_1v2.n785 5.02376
R5591 vss_1v2.n147 vss_1v2.n643 5.02376
R5592 vss_1v2.n148 vss_1v2.n786 5.02376
R5593 vss_1v2.n61 vss_1v2.n642 5.02376
R5594 vss_1v2.n62 vss_1v2.n788 5.02376
R5595 vss_1v2.n60 vss_1v2.n640 5.02376
R5596 vss_1v2.n63 vss_1v2.n790 5.02376
R5597 vss_1v2.n3552 vss_1v2.t57 4.93471
R5598 vss_1v2.n3544 vss_1v2.t60 4.93471
R5599 vss_1v2.n2468 vss_1v2.n1996 4.93471
R5600 vss_1v2.t210 vss_1v2.n342 4.93471
R5601 vss_1v2.t149 vss_1v2.n862 4.86905
R5602 vss_1v2.n253 vss_1v2.t153 4.86905
R5603 vss_1v2.n1308 vss_1v2.t101 4.86905
R5604 vss_1v2.t97 vss_1v2.n929 4.86905
R5605 vss_1v2.n4077 vss_1v2.n4076 4.85376
R5606 vss_1v2.n4088 vss_1v2.n4087 4.85088
R5607 vss_1v2.n2796 vss_1v2.t206 4.81136
R5608 vss_1v2.t6 vss_1v2.n601 4.8005
R5609 vss_1v2.t80 vss_1v2.n852 4.8005
R5610 vss_1v2.n191 vss_1v2.t309 4.68887
R5611 vss_1v2.t2 vss_1v2.n298 4.688
R5612 vss_1v2.n228 vss_1v2.t24 4.62562
R5613 vss_1v2.n2916 vss_1v2.n2915 4.56464
R5614 vss_1v2.n462 vss_1v2.n2802 4.564
R5615 vss_1v2.n3781 vss_1v2.n3780 4.53248
R5616 vss_1v2.n1624 vss_1v2.n1622 4.53248
R5617 vss_1v2.n1502 vss_1v2.n1457 4.5005
R5618 vss_1v2.n1501 vss_1v2.n1500 4.5005
R5619 vss_1v2.n1460 vss_1v2.n1459 4.5005
R5620 vss_1v2.n1495 vss_1v2.n1494 4.5005
R5621 vss_1v2.n1493 vss_1v2.n1464 4.5005
R5622 vss_1v2.n1492 vss_1v2.n1491 4.5005
R5623 vss_1v2.n1466 vss_1v2.n1465 4.5005
R5624 vss_1v2.n1485 vss_1v2.n1484 4.5005
R5625 vss_1v2.n1483 vss_1v2.n1470 4.5005
R5626 vss_1v2.n1482 vss_1v2.n1481 4.5005
R5627 vss_1v2.n1472 vss_1v2.n1471 4.5005
R5628 vss_1v2.n1475 vss_1v2.n1474 4.5005
R5629 vss_1v2.n491 vss_1v2.n489 4.5005
R5630 vss_1v2.n486 vss_1v2.n4151 4.5005
R5631 vss_1v2.n490 vss_1v2.n487 4.5005
R5632 vss_1v2.n1121 vss_1v2.n1120 4.5005
R5633 vss_1v2.n1122 vss_1v2.n1117 4.5005
R5634 vss_1v2.n1124 vss_1v2.n1123 4.5005
R5635 vss_1v2.n1114 vss_1v2.n1113 4.5005
R5636 vss_1v2.n1131 vss_1v2.n1130 4.5005
R5637 vss_1v2.n1132 vss_1v2.n1112 4.5005
R5638 vss_1v2.n1134 vss_1v2.n1133 4.5005
R5639 vss_1v2.n1108 vss_1v2.n1107 4.5005
R5640 vss_1v2.n1141 vss_1v2.n1140 4.5005
R5641 vss_1v2.n1142 vss_1v2.n1106 4.5005
R5642 vss_1v2.n1144 vss_1v2.n1143 4.5005
R5643 vss_1v2.n1102 vss_1v2.n1101 4.5005
R5644 vss_1v2.n1151 vss_1v2.n1150 4.5005
R5645 vss_1v2.n1152 vss_1v2.n1100 4.5005
R5646 vss_1v2.n1154 vss_1v2.n1153 4.5005
R5647 vss_1v2.n1096 vss_1v2.n1095 4.5005
R5648 vss_1v2.n1160 vss_1v2.n1159 4.5005
R5649 vss_1v2.n1161 vss_1v2.n1094 4.5005
R5650 vss_1v2.n1163 vss_1v2.n1162 4.5005
R5651 vss_1v2.n1091 vss_1v2.n1090 4.5005
R5652 vss_1v2.n1170 vss_1v2.n1169 4.5005
R5653 vss_1v2.n1171 vss_1v2.n1089 4.5005
R5654 vss_1v2.n1173 vss_1v2.n1172 4.5005
R5655 vss_1v2.n1085 vss_1v2.n1084 4.5005
R5656 vss_1v2.n1179 vss_1v2.n1178 4.5005
R5657 vss_1v2.n1180 vss_1v2.n1083 4.5005
R5658 vss_1v2.n1182 vss_1v2.n1181 4.5005
R5659 vss_1v2.n1079 vss_1v2.n1078 4.5005
R5660 vss_1v2.n1189 vss_1v2.n1188 4.5005
R5661 vss_1v2.n1190 vss_1v2.n1077 4.5005
R5662 vss_1v2.n1192 vss_1v2.n1191 4.5005
R5663 vss_1v2.n1073 vss_1v2.n1072 4.5005
R5664 vss_1v2.n1199 vss_1v2.n1198 4.5005
R5665 vss_1v2.n1200 vss_1v2.n1071 4.5005
R5666 vss_1v2.n1202 vss_1v2.n1201 4.5005
R5667 vss_1v2.n1067 vss_1v2.n1066 4.5005
R5668 vss_1v2.n1208 vss_1v2.n1207 4.5005
R5669 vss_1v2.n1209 vss_1v2.n1064 4.5005
R5670 vss_1v2.n1211 vss_1v2.n1210 4.5005
R5671 vss_1v2.n1065 vss_1v2.n1063 4.5005
R5672 vss_1v2.n947 vss_1v2.n946 4.5005
R5673 vss_1v2.n4140 vss_1v2.n4139 4.5005
R5674 vss_1v2.n4141 vss_1v2.n944 4.5005
R5675 vss_1v2.n4143 vss_1v2.n4142 4.5005
R5676 vss_1v2.n945 vss_1v2.n943 4.5005
R5677 vss_1v2.n3608 vss_1v2.n3606 4.5005
R5678 vss_1v2.n3610 vss_1v2.n3609 4.5005
R5679 vss_1v2.n3612 vss_1v2.n3605 4.5005
R5680 vss_1v2.n3615 vss_1v2.n3614 4.5005
R5681 vss_1v2.n3616 vss_1v2.n3603 4.5005
R5682 vss_1v2.n3618 vss_1v2.n3617 4.5005
R5683 vss_1v2.n3620 vss_1v2.n3601 4.5005
R5684 vss_1v2.n3623 vss_1v2.n3622 4.5005
R5685 vss_1v2.n3624 vss_1v2.n3599 4.5005
R5686 vss_1v2.n3626 vss_1v2.n3625 4.5005
R5687 vss_1v2.n3600 vss_1v2.n3597 4.5005
R5688 vss_1v2.n2656 vss_1v2.n2655 4.5005
R5689 vss_1v2.n3633 vss_1v2.n3632 4.5005
R5690 vss_1v2.n3634 vss_1v2.n2654 4.5005
R5691 vss_1v2.n3636 vss_1v2.n3635 4.5005
R5692 vss_1v2.n2636 vss_1v2.n2635 4.5005
R5693 vss_1v2.n3646 vss_1v2.n3645 4.5005
R5694 vss_1v2.n3647 vss_1v2.n2634 4.5005
R5695 vss_1v2.n3649 vss_1v2.n3648 4.5005
R5696 vss_1v2.n2626 vss_1v2.n2625 4.5005
R5697 vss_1v2.n3662 vss_1v2.n3661 4.5005
R5698 vss_1v2.n3663 vss_1v2.n2624 4.5005
R5699 vss_1v2.n3665 vss_1v2.n3664 4.5005
R5700 vss_1v2.n2616 vss_1v2.n2615 4.5005
R5701 vss_1v2.n3674 vss_1v2.n3673 4.5005
R5702 vss_1v2.n3675 vss_1v2.n2614 4.5005
R5703 vss_1v2.n3677 vss_1v2.n3676 4.5005
R5704 vss_1v2.n2605 vss_1v2.n2604 4.5005
R5705 vss_1v2.n3684 vss_1v2.n3683 4.5005
R5706 vss_1v2.n3685 vss_1v2.n2603 4.5005
R5707 vss_1v2.n3687 vss_1v2.n3686 4.5005
R5708 vss_1v2.n2594 vss_1v2.n2593 4.5005
R5709 vss_1v2.n3700 vss_1v2.n3699 4.5005
R5710 vss_1v2.n3701 vss_1v2.n2592 4.5005
R5711 vss_1v2.n3703 vss_1v2.n3702 4.5005
R5712 vss_1v2.n2582 vss_1v2.n2581 4.5005
R5713 vss_1v2.n3715 vss_1v2.n3714 4.5005
R5714 vss_1v2.n3716 vss_1v2.n2580 4.5005
R5715 vss_1v2.n3718 vss_1v2.n3717 4.5005
R5716 vss_1v2.n2573 vss_1v2.n2572 4.5005
R5717 vss_1v2.n3725 vss_1v2.n3724 4.5005
R5718 vss_1v2.n3726 vss_1v2.n2571 4.5005
R5719 vss_1v2.n3728 vss_1v2.n3727 4.5005
R5720 vss_1v2.n2563 vss_1v2.n2562 4.5005
R5721 vss_1v2.n3741 vss_1v2.n3740 4.5005
R5722 vss_1v2.n3742 vss_1v2.n2561 4.5005
R5723 vss_1v2.n3744 vss_1v2.n3743 4.5005
R5724 vss_1v2.n2552 vss_1v2.n2551 4.5005
R5725 vss_1v2.n3753 vss_1v2.n3752 4.5005
R5726 vss_1v2.n3754 vss_1v2.n2550 4.5005
R5727 vss_1v2.n3756 vss_1v2.n3755 4.5005
R5728 vss_1v2.n2541 vss_1v2.n2540 4.5005
R5729 vss_1v2.n3763 vss_1v2.n3762 4.5005
R5730 vss_1v2.n3764 vss_1v2.n2539 4.5005
R5731 vss_1v2.n3766 vss_1v2.n3765 4.5005
R5732 vss_1v2.n2531 vss_1v2.n2530 4.5005
R5733 vss_1v2.n3779 vss_1v2.n3778 4.5005
R5734 vss_1v2.n1833 vss_1v2.n1458 4.5005
R5735 vss_1v2.n1832 vss_1v2.n1831 4.5005
R5736 vss_1v2.n1504 vss_1v2.n1503 4.5005
R5737 vss_1v2.n1825 vss_1v2.n1824 4.5005
R5738 vss_1v2.n1823 vss_1v2.n1508 4.5005
R5739 vss_1v2.n1822 vss_1v2.n1821 4.5005
R5740 vss_1v2.n1510 vss_1v2.n1509 4.5005
R5741 vss_1v2.n1815 vss_1v2.n1814 4.5005
R5742 vss_1v2.n1813 vss_1v2.n1513 4.5005
R5743 vss_1v2.n1812 vss_1v2.n1811 4.5005
R5744 vss_1v2.n1515 vss_1v2.n1514 4.5005
R5745 vss_1v2.n1805 vss_1v2.n1804 4.5005
R5746 vss_1v2.n1803 vss_1v2.n1518 4.5005
R5747 vss_1v2.n1802 vss_1v2.n1801 4.5005
R5748 vss_1v2.n1520 vss_1v2.n1519 4.5005
R5749 vss_1v2.n1795 vss_1v2.n1794 4.5005
R5750 vss_1v2.n1793 vss_1v2.n1523 4.5005
R5751 vss_1v2.n1792 vss_1v2.n1791 4.5005
R5752 vss_1v2.n1525 vss_1v2.n1524 4.5005
R5753 vss_1v2.n1785 vss_1v2.n1784 4.5005
R5754 vss_1v2.n1783 vss_1v2.n1529 4.5005
R5755 vss_1v2.n1782 vss_1v2.n1781 4.5005
R5756 vss_1v2.n1531 vss_1v2.n1530 4.5005
R5757 vss_1v2.n1775 vss_1v2.n1774 4.5005
R5758 vss_1v2.n1773 vss_1v2.n1534 4.5005
R5759 vss_1v2.n1772 vss_1v2.n1771 4.5005
R5760 vss_1v2.n1536 vss_1v2.n1535 4.5005
R5761 vss_1v2.n1765 vss_1v2.n1764 4.5005
R5762 vss_1v2.n1763 vss_1v2.n1540 4.5005
R5763 vss_1v2.n1762 vss_1v2.n1761 4.5005
R5764 vss_1v2.n1542 vss_1v2.n1541 4.5005
R5765 vss_1v2.n1756 vss_1v2.n1755 4.5005
R5766 vss_1v2.n1754 vss_1v2.n1545 4.5005
R5767 vss_1v2.n1753 vss_1v2.n1752 4.5005
R5768 vss_1v2.n1547 vss_1v2.n1546 4.5005
R5769 vss_1v2.n1746 vss_1v2.n1745 4.5005
R5770 vss_1v2.n1744 vss_1v2.n1551 4.5005
R5771 vss_1v2.n1743 vss_1v2.n1742 4.5005
R5772 vss_1v2.n1553 vss_1v2.n1552 4.5005
R5773 vss_1v2.n1736 vss_1v2.n1735 4.5005
R5774 vss_1v2.n1734 vss_1v2.n1557 4.5005
R5775 vss_1v2.n1733 vss_1v2.n1732 4.5005
R5776 vss_1v2.n1559 vss_1v2.n1558 4.5005
R5777 vss_1v2.n1727 vss_1v2.n1726 4.5005
R5778 vss_1v2.n1725 vss_1v2.n1563 4.5005
R5779 vss_1v2.n1724 vss_1v2.n1723 4.5005
R5780 vss_1v2.n1565 vss_1v2.n1564 4.5005
R5781 vss_1v2.n1718 vss_1v2.n1717 4.5005
R5782 vss_1v2.n1716 vss_1v2.n1569 4.5005
R5783 vss_1v2.n1715 vss_1v2.n1714 4.5005
R5784 vss_1v2.n1571 vss_1v2.n1570 4.5005
R5785 vss_1v2.n1709 vss_1v2.n1708 4.5005
R5786 vss_1v2.n1707 vss_1v2.n1575 4.5005
R5787 vss_1v2.n1706 vss_1v2.n1705 4.5005
R5788 vss_1v2.n1577 vss_1v2.n1576 4.5005
R5789 vss_1v2.n1700 vss_1v2.n1699 4.5005
R5790 vss_1v2.n1698 vss_1v2.n1581 4.5005
R5791 vss_1v2.n1697 vss_1v2.n1696 4.5005
R5792 vss_1v2.n1583 vss_1v2.n1582 4.5005
R5793 vss_1v2.n1691 vss_1v2.n1690 4.5005
R5794 vss_1v2.n1689 vss_1v2.n1587 4.5005
R5795 vss_1v2.n1688 vss_1v2.n1687 4.5005
R5796 vss_1v2.n1589 vss_1v2.n1588 4.5005
R5797 vss_1v2.n1681 vss_1v2.n1680 4.5005
R5798 vss_1v2.n1679 vss_1v2.n1593 4.5005
R5799 vss_1v2.n1678 vss_1v2.n1677 4.5005
R5800 vss_1v2.n1595 vss_1v2.n1594 4.5005
R5801 vss_1v2.n1672 vss_1v2.n1671 4.5005
R5802 vss_1v2.n1670 vss_1v2.n1599 4.5005
R5803 vss_1v2.n1669 vss_1v2.n1668 4.5005
R5804 vss_1v2.n1601 vss_1v2.n1600 4.5005
R5805 vss_1v2.n1663 vss_1v2.n1662 4.5005
R5806 vss_1v2.n1661 vss_1v2.n1605 4.5005
R5807 vss_1v2.n1660 vss_1v2.n1659 4.5005
R5808 vss_1v2.n1607 vss_1v2.n1606 4.5005
R5809 vss_1v2.n1653 vss_1v2.n1652 4.5005
R5810 vss_1v2.n1651 vss_1v2.n1610 4.5005
R5811 vss_1v2.n1650 vss_1v2.n1649 4.5005
R5812 vss_1v2.n1612 vss_1v2.n1611 4.5005
R5813 vss_1v2.n1643 vss_1v2.n1642 4.5005
R5814 vss_1v2.n1641 vss_1v2.n1616 4.5005
R5815 vss_1v2.n1640 vss_1v2.n1639 4.5005
R5816 vss_1v2.n1618 vss_1v2.n1617 4.5005
R5817 vss_1v2.n1633 vss_1v2.n1632 4.5005
R5818 vss_1v2.n1631 vss_1v2.n1621 4.5005
R5819 vss_1v2.n1630 vss_1v2.n1629 4.5005
R5820 vss_1v2.n1835 vss_1v2.n1834 4.5005
R5821 vss_1v2.n1457 vss_1v2.n1454 4.5005
R5822 vss_1v2.n1500 vss_1v2.n1499 4.5005
R5823 vss_1v2.n1497 vss_1v2.n1460 4.5005
R5824 vss_1v2.n1496 vss_1v2.n1495 4.5005
R5825 vss_1v2.n1464 vss_1v2.n1462 4.5005
R5826 vss_1v2.n1491 vss_1v2.n1490 4.5005
R5827 vss_1v2.n1488 vss_1v2.n1466 4.5005
R5828 vss_1v2.n1486 vss_1v2.n1485 4.5005
R5829 vss_1v2.n1470 vss_1v2.n1468 4.5005
R5830 vss_1v2.n1481 vss_1v2.n1480 4.5005
R5831 vss_1v2.n1478 vss_1v2.n1472 4.5005
R5832 vss_1v2.n1476 vss_1v2.n1475 4.5005
R5833 vss_1v2.n493 vss_1v2.n491 4.5005
R5834 vss_1v2.n4151 vss_1v2.n4150 4.5005
R5835 vss_1v2.n492 vss_1v2.n490 4.5005
R5836 vss_1v2.n1120 vss_1v2.n1119 4.5005
R5837 vss_1v2.n1117 vss_1v2.n1115 4.5005
R5838 vss_1v2.n1125 vss_1v2.n1124 4.5005
R5839 vss_1v2.n1127 vss_1v2.n1114 4.5005
R5840 vss_1v2.n1130 vss_1v2.n1129 4.5005
R5841 vss_1v2.n1112 vss_1v2.n1110 4.5005
R5842 vss_1v2.n1135 vss_1v2.n1134 4.5005
R5843 vss_1v2.n1137 vss_1v2.n1108 4.5005
R5844 vss_1v2.n1140 vss_1v2.n1139 4.5005
R5845 vss_1v2.n1106 vss_1v2.n1104 4.5005
R5846 vss_1v2.n1145 vss_1v2.n1144 4.5005
R5847 vss_1v2.n1147 vss_1v2.n1102 4.5005
R5848 vss_1v2.n1150 vss_1v2.n1149 4.5005
R5849 vss_1v2.n1100 vss_1v2.n1098 4.5005
R5850 vss_1v2.n1155 vss_1v2.n1154 4.5005
R5851 vss_1v2.n1157 vss_1v2.n1096 4.5005
R5852 vss_1v2.n1159 vss_1v2.n1158 4.5005
R5853 vss_1v2.n1094 vss_1v2.n1093 4.5005
R5854 vss_1v2.n1164 vss_1v2.n1163 4.5005
R5855 vss_1v2.n1166 vss_1v2.n1091 4.5005
R5856 vss_1v2.n1169 vss_1v2.n1168 4.5005
R5857 vss_1v2.n1089 vss_1v2.n1087 4.5005
R5858 vss_1v2.n1174 vss_1v2.n1173 4.5005
R5859 vss_1v2.n1175 vss_1v2.n1085 4.5005
R5860 vss_1v2.n1178 vss_1v2.n1177 4.5005
R5861 vss_1v2.n1083 vss_1v2.n1081 4.5005
R5862 vss_1v2.n1183 vss_1v2.n1182 4.5005
R5863 vss_1v2.n1185 vss_1v2.n1079 4.5005
R5864 vss_1v2.n1188 vss_1v2.n1187 4.5005
R5865 vss_1v2.n1077 vss_1v2.n1075 4.5005
R5866 vss_1v2.n1193 vss_1v2.n1192 4.5005
R5867 vss_1v2.n1195 vss_1v2.n1073 4.5005
R5868 vss_1v2.n1198 vss_1v2.n1197 4.5005
R5869 vss_1v2.n1071 vss_1v2.n1069 4.5005
R5870 vss_1v2.n1203 vss_1v2.n1202 4.5005
R5871 vss_1v2.n1204 vss_1v2.n1067 4.5005
R5872 vss_1v2.n1207 vss_1v2.n1206 4.5005
R5873 vss_1v2.n1064 vss_1v2.n1062 4.5005
R5874 vss_1v2.n1212 vss_1v2.n1211 4.5005
R5875 vss_1v2.n1063 vss_1v2.n1060 4.5005
R5876 vss_1v2.n948 vss_1v2.n947 4.5005
R5877 vss_1v2.n4139 vss_1v2.n4138 4.5005
R5878 vss_1v2.n944 vss_1v2.n942 4.5005
R5879 vss_1v2.n4144 vss_1v2.n4143 4.5005
R5880 vss_1v2.n943 vss_1v2.n941 4.5005
R5881 vss_1v2.n3606 vss_1v2.n3591 4.5005
R5882 vss_1v2.n3610 vss_1v2.n3607 4.5005
R5883 vss_1v2.n3612 vss_1v2.n3611 4.5005
R5884 vss_1v2.n3614 vss_1v2.n3613 4.5005
R5885 vss_1v2.n3603 vss_1v2.n3602 4.5005
R5886 vss_1v2.n3618 vss_1v2.n3604 4.5005
R5887 vss_1v2.n3620 vss_1v2.n3619 4.5005
R5888 vss_1v2.n3622 vss_1v2.n3621 4.5005
R5889 vss_1v2.n3599 vss_1v2.n3598 4.5005
R5890 vss_1v2.n3627 vss_1v2.n3626 4.5005
R5891 vss_1v2.n3597 vss_1v2.n3596 4.5005
R5892 vss_1v2.n2657 vss_1v2.n2656 4.5005
R5893 vss_1v2.n3632 vss_1v2.n3631 4.5005
R5894 vss_1v2.n2654 vss_1v2.n2653 4.5005
R5895 vss_1v2.n3637 vss_1v2.n3636 4.5005
R5896 vss_1v2.n2637 vss_1v2.n2636 4.5005
R5897 vss_1v2.n3645 vss_1v2.n3644 4.5005
R5898 vss_1v2.n2634 vss_1v2.n2633 4.5005
R5899 vss_1v2.n3650 vss_1v2.n3649 4.5005
R5900 vss_1v2.n2627 vss_1v2.n2626 4.5005
R5901 vss_1v2.n3661 vss_1v2.n3660 4.5005
R5902 vss_1v2.n2624 vss_1v2.n2623 4.5005
R5903 vss_1v2.n3666 vss_1v2.n3665 4.5005
R5904 vss_1v2.n2617 vss_1v2.n2616 4.5005
R5905 vss_1v2.n3673 vss_1v2.n3672 4.5005
R5906 vss_1v2.n2614 vss_1v2.n2613 4.5005
R5907 vss_1v2.n3678 vss_1v2.n3677 4.5005
R5908 vss_1v2.n456 vss_1v2.n2605 4.5005
R5909 vss_1v2.n3683 vss_1v2.n3682 4.5005
R5910 vss_1v2.n2603 vss_1v2.n2602 4.5005
R5911 vss_1v2.n3688 vss_1v2.n3687 4.5005
R5912 vss_1v2.n2595 vss_1v2.n2594 4.5005
R5913 vss_1v2.n3699 vss_1v2.n3698 4.5005
R5914 vss_1v2.n2592 vss_1v2.n2591 4.5005
R5915 vss_1v2.n3704 vss_1v2.n3703 4.5005
R5916 vss_1v2.n2583 vss_1v2.n2582 4.5005
R5917 vss_1v2.n3714 vss_1v2.n3713 4.5005
R5918 vss_1v2.n2580 vss_1v2.n2579 4.5005
R5919 vss_1v2.n3719 vss_1v2.n3718 4.5005
R5920 vss_1v2.n479 vss_1v2.n2573 4.5005
R5921 vss_1v2.n3724 vss_1v2.n3723 4.5005
R5922 vss_1v2.n2571 vss_1v2.n2570 4.5005
R5923 vss_1v2.n3729 vss_1v2.n3728 4.5005
R5924 vss_1v2.n2564 vss_1v2.n2563 4.5005
R5925 vss_1v2.n3740 vss_1v2.n3739 4.5005
R5926 vss_1v2.n2561 vss_1v2.n2560 4.5005
R5927 vss_1v2.n3745 vss_1v2.n3744 4.5005
R5928 vss_1v2.n2553 vss_1v2.n2552 4.5005
R5929 vss_1v2.n3752 vss_1v2.n3751 4.5005
R5930 vss_1v2.n2550 vss_1v2.n2549 4.5005
R5931 vss_1v2.n3757 vss_1v2.n3756 4.5005
R5932 vss_1v2.n458 vss_1v2.n2541 4.5005
R5933 vss_1v2.n3762 vss_1v2.n3761 4.5005
R5934 vss_1v2.n2539 vss_1v2.n2538 4.5005
R5935 vss_1v2.n3767 vss_1v2.n3766 4.5005
R5936 vss_1v2.n2532 vss_1v2.n2531 4.5005
R5937 vss_1v2.n3778 vss_1v2.n3777 4.5005
R5938 vss_1v2.n2529 vss_1v2.n2528 4.5005
R5939 vss_1v2.n1458 vss_1v2.n1456 4.5005
R5940 vss_1v2.n1831 vss_1v2.n1830 4.5005
R5941 vss_1v2.n1828 vss_1v2.n1504 4.5005
R5942 vss_1v2.n1826 vss_1v2.n1825 4.5005
R5943 vss_1v2.n1508 vss_1v2.n1506 4.5005
R5944 vss_1v2.n1821 vss_1v2.n1820 4.5005
R5945 vss_1v2.n1818 vss_1v2.n1510 4.5005
R5946 vss_1v2.n1816 vss_1v2.n1815 4.5005
R5947 vss_1v2.n1513 vss_1v2.n1512 4.5005
R5948 vss_1v2.n1811 vss_1v2.n1810 4.5005
R5949 vss_1v2.n1808 vss_1v2.n1515 4.5005
R5950 vss_1v2.n1806 vss_1v2.n1805 4.5005
R5951 vss_1v2.n1518 vss_1v2.n1516 4.5005
R5952 vss_1v2.n1801 vss_1v2.n1800 4.5005
R5953 vss_1v2.n1798 vss_1v2.n1520 4.5005
R5954 vss_1v2.n1796 vss_1v2.n1795 4.5005
R5955 vss_1v2.n1523 vss_1v2.n1522 4.5005
R5956 vss_1v2.n1791 vss_1v2.n1790 4.5005
R5957 vss_1v2.n1788 vss_1v2.n1525 4.5005
R5958 vss_1v2.n1786 vss_1v2.n1785 4.5005
R5959 vss_1v2.n1529 vss_1v2.n1527 4.5005
R5960 vss_1v2.n1781 vss_1v2.n1780 4.5005
R5961 vss_1v2.n1778 vss_1v2.n1531 4.5005
R5962 vss_1v2.n1776 vss_1v2.n1775 4.5005
R5963 vss_1v2.n1534 vss_1v2.n1532 4.5005
R5964 vss_1v2.n1771 vss_1v2.n1770 4.5005
R5965 vss_1v2.n1768 vss_1v2.n1536 4.5005
R5966 vss_1v2.n1766 vss_1v2.n1765 4.5005
R5967 vss_1v2.n1540 vss_1v2.n1538 4.5005
R5968 vss_1v2.n1761 vss_1v2.n1760 4.5005
R5969 vss_1v2.n1759 vss_1v2.n1542 4.5005
R5970 vss_1v2.n1757 vss_1v2.n1756 4.5005
R5971 vss_1v2.n1545 vss_1v2.n1543 4.5005
R5972 vss_1v2.n1752 vss_1v2.n1751 4.5005
R5973 vss_1v2.n1749 vss_1v2.n1547 4.5005
R5974 vss_1v2.n1747 vss_1v2.n1746 4.5005
R5975 vss_1v2.n1551 vss_1v2.n1549 4.5005
R5976 vss_1v2.n1742 vss_1v2.n1741 4.5005
R5977 vss_1v2.n1739 vss_1v2.n1553 4.5005
R5978 vss_1v2.n1737 vss_1v2.n1736 4.5005
R5979 vss_1v2.n1557 vss_1v2.n1555 4.5005
R5980 vss_1v2.n1732 vss_1v2.n1731 4.5005
R5981 vss_1v2.n1730 vss_1v2.n1559 4.5005
R5982 vss_1v2.n1728 vss_1v2.n1727 4.5005
R5983 vss_1v2.n1563 vss_1v2.n1561 4.5005
R5984 vss_1v2.n1723 vss_1v2.n1722 4.5005
R5985 vss_1v2.n1720 vss_1v2.n1565 4.5005
R5986 vss_1v2.n1719 vss_1v2.n1718 4.5005
R5987 vss_1v2.n1569 vss_1v2.n1567 4.5005
R5988 vss_1v2.n1714 vss_1v2.n1713 4.5005
R5989 vss_1v2.n1712 vss_1v2.n1571 4.5005
R5990 vss_1v2.n1710 vss_1v2.n1709 4.5005
R5991 vss_1v2.n1575 vss_1v2.n1573 4.5005
R5992 vss_1v2.n1705 vss_1v2.n1704 4.5005
R5993 vss_1v2.n1703 vss_1v2.n1577 4.5005
R5994 vss_1v2.n1701 vss_1v2.n1700 4.5005
R5995 vss_1v2.n1581 vss_1v2.n1579 4.5005
R5996 vss_1v2.n1696 vss_1v2.n1695 4.5005
R5997 vss_1v2.n1693 vss_1v2.n1583 4.5005
R5998 vss_1v2.n1692 vss_1v2.n1691 4.5005
R5999 vss_1v2.n1587 vss_1v2.n1585 4.5005
R6000 vss_1v2.n1687 vss_1v2.n1686 4.5005
R6001 vss_1v2.n1684 vss_1v2.n1589 4.5005
R6002 vss_1v2.n1682 vss_1v2.n1681 4.5005
R6003 vss_1v2.n1593 vss_1v2.n1591 4.5005
R6004 vss_1v2.n1677 vss_1v2.n1676 4.5005
R6005 vss_1v2.n1674 vss_1v2.n1595 4.5005
R6006 vss_1v2.n1673 vss_1v2.n1672 4.5005
R6007 vss_1v2.n1599 vss_1v2.n1597 4.5005
R6008 vss_1v2.n1668 vss_1v2.n1667 4.5005
R6009 vss_1v2.n1665 vss_1v2.n1601 4.5005
R6010 vss_1v2.n1664 vss_1v2.n1663 4.5005
R6011 vss_1v2.n1605 vss_1v2.n1603 4.5005
R6012 vss_1v2.n1659 vss_1v2.n1658 4.5005
R6013 vss_1v2.n1656 vss_1v2.n1607 4.5005
R6014 vss_1v2.n1654 vss_1v2.n1653 4.5005
R6015 vss_1v2.n1610 vss_1v2.n1609 4.5005
R6016 vss_1v2.n1649 vss_1v2.n1648 4.5005
R6017 vss_1v2.n1646 vss_1v2.n1612 4.5005
R6018 vss_1v2.n1644 vss_1v2.n1643 4.5005
R6019 vss_1v2.n1616 vss_1v2.n1614 4.5005
R6020 vss_1v2.n1639 vss_1v2.n1638 4.5005
R6021 vss_1v2.n1636 vss_1v2.n1618 4.5005
R6022 vss_1v2.n1634 vss_1v2.n1633 4.5005
R6023 vss_1v2.n1621 vss_1v2.n1620 4.5005
R6024 vss_1v2.n1629 vss_1v2.n1628 4.5005
R6025 vss_1v2.n1626 vss_1v2.n1623 4.5005
R6026 vss_1v2.n1836 vss_1v2.n1835 4.5005
R6027 vss_1v2.n1454 vss_1v2.n857 4.5005
R6028 vss_1v2.n1499 vss_1v2.n1498 4.5005
R6029 vss_1v2.n1497 vss_1v2.n436 4.5005
R6030 vss_1v2.n1496 vss_1v2.n1463 4.5005
R6031 vss_1v2.n1462 vss_1v2.n1461 4.5005
R6032 vss_1v2.n1490 vss_1v2.n1489 4.5005
R6033 vss_1v2.n1488 vss_1v2.n1487 4.5005
R6034 vss_1v2.n1486 vss_1v2.n1469 4.5005
R6035 vss_1v2.n1468 vss_1v2.n1467 4.5005
R6036 vss_1v2.n1480 vss_1v2.n1479 4.5005
R6037 vss_1v2.n1478 vss_1v2.n1477 4.5005
R6038 vss_1v2.n1476 vss_1v2.n1473 4.5005
R6039 vss_1v2.n1000 vss_1v2.n493 4.5005
R6040 vss_1v2.n4150 vss_1v2.n4149 4.5005
R6041 vss_1v2.n1017 vss_1v2.n492 4.5005
R6042 vss_1v2.n1119 vss_1v2.n1118 4.5005
R6043 vss_1v2.n1115 vss_1v2.n874 4.5005
R6044 vss_1v2.n1125 vss_1v2.n1116 4.5005
R6045 vss_1v2.n1127 vss_1v2.n1126 4.5005
R6046 vss_1v2.n1129 vss_1v2.n1128 4.5005
R6047 vss_1v2.n1110 vss_1v2.n1109 4.5005
R6048 vss_1v2.n1135 vss_1v2.n1111 4.5005
R6049 vss_1v2.n1137 vss_1v2.n1136 4.5005
R6050 vss_1v2.n1139 vss_1v2.n1138 4.5005
R6051 vss_1v2.n1104 vss_1v2.n1103 4.5005
R6052 vss_1v2.n1145 vss_1v2.n1105 4.5005
R6053 vss_1v2.n1147 vss_1v2.n1146 4.5005
R6054 vss_1v2.n1149 vss_1v2.n1148 4.5005
R6055 vss_1v2.n1098 vss_1v2.n1097 4.5005
R6056 vss_1v2.n1155 vss_1v2.n1099 4.5005
R6057 vss_1v2.n1157 vss_1v2.n1156 4.5005
R6058 vss_1v2.n1158 vss_1v2.n1029 4.5005
R6059 vss_1v2.n1093 vss_1v2.n1092 4.5005
R6060 vss_1v2.n1164 vss_1v2.n898 4.5005
R6061 vss_1v2.n1166 vss_1v2.n1165 4.5005
R6062 vss_1v2.n1168 vss_1v2.n1167 4.5005
R6063 vss_1v2.n1087 vss_1v2.n1086 4.5005
R6064 vss_1v2.n1174 vss_1v2.n1088 4.5005
R6065 vss_1v2.n1175 vss_1v2.n978 4.5005
R6066 vss_1v2.n1177 vss_1v2.n1176 4.5005
R6067 vss_1v2.n1081 vss_1v2.n1080 4.5005
R6068 vss_1v2.n1183 vss_1v2.n1082 4.5005
R6069 vss_1v2.n1185 vss_1v2.n1184 4.5005
R6070 vss_1v2.n1187 vss_1v2.n1186 4.5005
R6071 vss_1v2.n1075 vss_1v2.n1074 4.5005
R6072 vss_1v2.n1193 vss_1v2.n1076 4.5005
R6073 vss_1v2.n1195 vss_1v2.n1194 4.5005
R6074 vss_1v2.n1197 vss_1v2.n1196 4.5005
R6075 vss_1v2.n1069 vss_1v2.n1068 4.5005
R6076 vss_1v2.n1203 vss_1v2.n1070 4.5005
R6077 vss_1v2.n1204 vss_1v2.n922 4.5005
R6078 vss_1v2.n1206 vss_1v2.n1205 4.5005
R6079 vss_1v2.n1062 vss_1v2.n1061 4.5005
R6080 vss_1v2.n1213 vss_1v2.n1212 4.5005
R6081 vss_1v2.n1060 vss_1v2.n1059 4.5005
R6082 vss_1v2.n955 vss_1v2.n948 4.5005
R6083 vss_1v2.n4138 vss_1v2.n4137 4.5005
R6084 vss_1v2.n952 vss_1v2.n942 4.5005
R6085 vss_1v2.n4145 vss_1v2.n4144 4.5005
R6086 vss_1v2.n3644 vss_1v2.n3643 4.5005
R6087 vss_1v2.n2640 vss_1v2.n2633 4.5005
R6088 vss_1v2.n3651 vss_1v2.n3650 4.5005
R6089 vss_1v2.n3654 vss_1v2.n2627 4.5005
R6090 vss_1v2.n3660 vss_1v2.n3659 4.5005
R6091 vss_1v2.n2629 vss_1v2.n2623 4.5005
R6092 vss_1v2.n431 vss_1v2.n3666 4.5005
R6093 vss_1v2.n3668 vss_1v2.n2617 4.5005
R6094 vss_1v2.n3672 vss_1v2.n3671 4.5005
R6095 vss_1v2.n2619 vss_1v2.n2613 4.5005
R6096 vss_1v2.n3679 vss_1v2.n3678 4.5005
R6097 vss_1v2.n422 vss_1v2.n456 4.5005
R6098 vss_1v2.n3682 vss_1v2.n3681 4.5005
R6099 vss_1v2.n2608 vss_1v2.n2602 4.5005
R6100 vss_1v2.n3689 vss_1v2.n3688 4.5005
R6101 vss_1v2.n3692 vss_1v2.n2595 4.5005
R6102 vss_1v2.n3698 vss_1v2.n3697 4.5005
R6103 vss_1v2.n2598 vss_1v2.n2591 4.5005
R6104 vss_1v2.n3705 vss_1v2.n3704 4.5005
R6105 vss_1v2.n3709 vss_1v2.n2583 4.5005
R6106 vss_1v2.n3713 vss_1v2.n3712 4.5005
R6107 vss_1v2.n2585 vss_1v2.n2579 4.5005
R6108 vss_1v2.n3720 vss_1v2.n3719 4.5005
R6109 vss_1v2.n429 vss_1v2.n479 4.5005
R6110 vss_1v2.n3723 vss_1v2.n3722 4.5005
R6111 vss_1v2.n2575 vss_1v2.n2570 4.5005
R6112 vss_1v2.n3730 vss_1v2.n3729 4.5005
R6113 vss_1v2.n3733 vss_1v2.n2564 4.5005
R6114 vss_1v2.n3739 vss_1v2.n3738 4.5005
R6115 vss_1v2.n2566 vss_1v2.n2560 4.5005
R6116 vss_1v2.n449 vss_1v2.n3745 4.5005
R6117 vss_1v2.n3747 vss_1v2.n2553 4.5005
R6118 vss_1v2.n3751 vss_1v2.n3750 4.5005
R6119 vss_1v2.n2555 vss_1v2.n2549 4.5005
R6120 vss_1v2.n3758 vss_1v2.n3757 4.5005
R6121 vss_1v2.n447 vss_1v2.n458 4.5005
R6122 vss_1v2.n3761 vss_1v2.n3760 4.5005
R6123 vss_1v2.n2545 vss_1v2.n2538 4.5005
R6124 vss_1v2.n3768 vss_1v2.n3767 4.5005
R6125 vss_1v2.n3771 vss_1v2.n2532 4.5005
R6126 vss_1v2.n3777 vss_1v2.n3776 4.5005
R6127 vss_1v2.n2534 vss_1v2.n2528 4.5005
R6128 vss_1v2.n3782 vss_1v2.n3781 4.5005
R6129 vss_1v2.n1837 vss_1v2.n1836 4.5005
R6130 vss_1v2.n1456 vss_1v2.n1455 4.5005
R6131 vss_1v2.n1830 vss_1v2.n1829 4.5005
R6132 vss_1v2.n1828 vss_1v2.n1827 4.5005
R6133 vss_1v2.n1826 vss_1v2.n1507 4.5005
R6134 vss_1v2.n1506 vss_1v2.n1505 4.5005
R6135 vss_1v2.n1820 vss_1v2.n1819 4.5005
R6136 vss_1v2.n1818 vss_1v2.n1817 4.5005
R6137 vss_1v2.n1816 vss_1v2.n397 4.5005
R6138 vss_1v2.n1512 vss_1v2.n1511 4.5005
R6139 vss_1v2.n1810 vss_1v2.n1809 4.5005
R6140 vss_1v2.n1808 vss_1v2.n1807 4.5005
R6141 vss_1v2.n1806 vss_1v2.n1517 4.5005
R6142 vss_1v2.n1516 vss_1v2.n409 4.5005
R6143 vss_1v2.n1800 vss_1v2.n1799 4.5005
R6144 vss_1v2.n1798 vss_1v2.n1797 4.5005
R6145 vss_1v2.n1796 vss_1v2.n835 4.5005
R6146 vss_1v2.n1522 vss_1v2.n1521 4.5005
R6147 vss_1v2.n1790 vss_1v2.n1789 4.5005
R6148 vss_1v2.n1788 vss_1v2.n1787 4.5005
R6149 vss_1v2.n1786 vss_1v2.n1528 4.5005
R6150 vss_1v2.n1527 vss_1v2.n1526 4.5005
R6151 vss_1v2.n1780 vss_1v2.n1779 4.5005
R6152 vss_1v2.n1778 vss_1v2.n1777 4.5005
R6153 vss_1v2.n1776 vss_1v2.n1533 4.5005
R6154 vss_1v2.n1532 vss_1v2.n400 4.5005
R6155 vss_1v2.n1770 vss_1v2.n1769 4.5005
R6156 vss_1v2.n1768 vss_1v2.n1767 4.5005
R6157 vss_1v2.n1766 vss_1v2.n1539 4.5005
R6158 vss_1v2.n1538 vss_1v2.n1537 4.5005
R6159 vss_1v2.n1760 vss_1v2.n412 4.5005
R6160 vss_1v2.n1759 vss_1v2.n1758 4.5005
R6161 vss_1v2.n1757 vss_1v2.n1544 4.5005
R6162 vss_1v2.n1543 vss_1v2.n813 4.5005
R6163 vss_1v2.n1751 vss_1v2.n1750 4.5005
R6164 vss_1v2.n1749 vss_1v2.n1748 4.5005
R6165 vss_1v2.n1747 vss_1v2.n1550 4.5005
R6166 vss_1v2.n1549 vss_1v2.n1548 4.5005
R6167 vss_1v2.n1741 vss_1v2.n1740 4.5005
R6168 vss_1v2.n1739 vss_1v2.n1738 4.5005
R6169 vss_1v2.n1737 vss_1v2.n1556 4.5005
R6170 vss_1v2.n1555 vss_1v2.n1554 4.5005
R6171 vss_1v2.n1731 vss_1v2.n403 4.5005
R6172 vss_1v2.n1730 vss_1v2.n1729 4.5005
R6173 vss_1v2.n1728 vss_1v2.n1562 4.5005
R6174 vss_1v2.n1561 vss_1v2.n1560 4.5005
R6175 vss_1v2.n1722 vss_1v2.n1721 4.5005
R6176 vss_1v2.n1720 vss_1v2.n415 4.5005
R6177 vss_1v2.n1719 vss_1v2.n1568 4.5005
R6178 vss_1v2.n1567 vss_1v2.n1566 4.5005
R6179 vss_1v2.n1713 vss_1v2.n791 4.5005
R6180 vss_1v2.n1712 vss_1v2.n1711 4.5005
R6181 vss_1v2.n1710 vss_1v2.n1574 4.5005
R6182 vss_1v2.n1573 vss_1v2.n1572 4.5005
R6183 vss_1v2.n1704 vss_1v2.n379 4.5005
R6184 vss_1v2.n1703 vss_1v2.n1702 4.5005
R6185 vss_1v2.n1701 vss_1v2.n1580 4.5005
R6186 vss_1v2.n1579 vss_1v2.n1578 4.5005
R6187 vss_1v2.n1695 vss_1v2.n1694 4.5005
R6188 vss_1v2.n1693 vss_1v2.n389 4.5005
R6189 vss_1v2.n1692 vss_1v2.n1586 4.5005
R6190 vss_1v2.n1585 vss_1v2.n1584 4.5005
R6191 vss_1v2.n1686 vss_1v2.n1685 4.5005
R6192 vss_1v2.n1684 vss_1v2.n1683 4.5005
R6193 vss_1v2.n1682 vss_1v2.n1592 4.5005
R6194 vss_1v2.n1591 vss_1v2.n1590 4.5005
R6195 vss_1v2.n1676 vss_1v2.n1675 4.5005
R6196 vss_1v2.n1674 vss_1v2.n769 4.5005
R6197 vss_1v2.n1673 vss_1v2.n1598 4.5005
R6198 vss_1v2.n1597 vss_1v2.n1596 4.5005
R6199 vss_1v2.n1667 vss_1v2.n1666 4.5005
R6200 vss_1v2.n1665 vss_1v2.n382 4.5005
R6201 vss_1v2.n1664 vss_1v2.n1604 4.5005
R6202 vss_1v2.n1603 vss_1v2.n1602 4.5005
R6203 vss_1v2.n1658 vss_1v2.n1657 4.5005
R6204 vss_1v2.n1656 vss_1v2.n1655 4.5005
R6205 vss_1v2.n1654 vss_1v2.n392 4.5005
R6206 vss_1v2.n1609 vss_1v2.n1608 4.5005
R6207 vss_1v2.n1648 vss_1v2.n1647 4.5005
R6208 vss_1v2.n1646 vss_1v2.n1645 4.5005
R6209 vss_1v2.n1644 vss_1v2.n1615 4.5005
R6210 vss_1v2.n1614 vss_1v2.n1613 4.5005
R6211 vss_1v2.n1638 vss_1v2.n1637 4.5005
R6212 vss_1v2.n1636 vss_1v2.n1635 4.5005
R6213 vss_1v2.n1634 vss_1v2.n747 4.5005
R6214 vss_1v2.n1620 vss_1v2.n1619 4.5005
R6215 vss_1v2.n1628 vss_1v2.n1627 4.5005
R6216 vss_1v2.n1626 vss_1v2.n1625 4.5005
R6217 vss_1v2.n1624 vss_1v2.n385 4.5005
R6218 vss_1v2.n4109 vss_1v2.n4108 4.5005
R6219 vss_1v2.n4111 vss_1v2.n4110 4.5005
R6220 vss_1v2.n2644 vss_1v2.n941 4.49932
R6221 vss_1v2.t41 vss_1v2.n264 4.49077
R6222 vss_1v2.n3629 vss_1v2.n3592 4.48552
R6223 vss_1v2.n3629 vss_1v2.n3593 4.48552
R6224 vss_1v2.n3629 vss_1v2.n3594 4.48552
R6225 vss_1v2.n3629 vss_1v2.n3595 4.48552
R6226 vss_1v2.n3629 vss_1v2.n3628 4.48552
R6227 vss_1v2.n3630 vss_1v2.n3629 4.48552
R6228 vss_1v2.n3629 vss_1v2.n2652 4.48552
R6229 vss_1v2.n3639 vss_1v2.n3638 4.48552
R6230 vss_1v2.n3639 vss_1v2.n2651 4.48552
R6231 vss_1v2.n3639 vss_1v2.n2650 4.48552
R6232 vss_1v2.n3639 vss_1v2.n2649 4.48552
R6233 vss_1v2.n3639 vss_1v2.n2648 4.48552
R6234 vss_1v2.n3639 vss_1v2.n2647 4.48552
R6235 vss_1v2.n3639 vss_1v2.n2646 4.48552
R6236 vss_1v2.n3639 vss_1v2.n2645 4.48552
R6237 vss_1v2.n181 vss_1v2.t318 4.46562
R6238 vss_1v2.t293 vss_1v2.n282 4.44129
R6239 vss_1v2.n4046 vss_1v2.n3 0.00442543
R6240 vss_1v2.n64 vss_1v2.n792 4.39491
R6241 vss_1v2.t247 vss_1v2.n563 4.38219
R6242 vss_1v2.n244 vss_1v2.t270 4.38219
R6243 vss_1v2.n3180 vss_1v2.n43 4.37079
R6244 vss_1v2.n44 vss_1v2.n727 4.35399
R6245 vss_1v2.n4117 vss_1v2.n701 4.35399
R6246 vss_1v2.t331 vss_1v2.n1991 4.31793
R6247 vss_1v2.n1999 vss_1v2.n1968 4.2623
R6248 vss_1v2.n4020 vss_1v2.n1968 4.2623
R6249 vss_1v2.n37 vss_1v2.t46 0.359416
R6250 vss_1v2.n3558 vss_1v2.n2847 4.25113
R6251 vss_1v2.n3569 vss_1v2.n2808 4.25113
R6252 vss_1v2.n2697 vss_1v2.n310 4.251
R6253 vss_1v2.n12 vss_1v2.n714 4.25095
R6254 vss_1v2.n4133 vss_1v2.n223 4.2505
R6255 vss_1v2.n4133 vss_1v2.n224 4.2505
R6256 vss_1v2.n4133 vss_1v2.n225 4.2505
R6257 vss_1v2.n4133 vss_1v2.n226 4.2505
R6258 vss_1v2.n4133 vss_1v2.n227 4.2505
R6259 vss_1v2.n4133 vss_1v2.n228 4.2505
R6260 vss_1v2.n4133 vss_1v2.n229 4.2505
R6261 vss_1v2.n4133 vss_1v2.n230 4.2505
R6262 vss_1v2.n4133 vss_1v2.n231 4.2505
R6263 vss_1v2.n4133 vss_1v2.n232 4.2505
R6264 vss_1v2.n4133 vss_1v2.n233 4.2505
R6265 vss_1v2.n4133 vss_1v2.n234 4.2505
R6266 vss_1v2.n4133 vss_1v2.n235 4.2505
R6267 vss_1v2.n4133 vss_1v2.n236 4.2505
R6268 vss_1v2.n4133 vss_1v2.n237 4.2505
R6269 vss_1v2.n4133 vss_1v2.n238 4.2505
R6270 vss_1v2.n4133 vss_1v2.n239 4.2505
R6271 vss_1v2.n4133 vss_1v2.n240 4.2505
R6272 vss_1v2.n4133 vss_1v2.n241 4.2505
R6273 vss_1v2.n4133 vss_1v2.n242 4.2505
R6274 vss_1v2.n4133 vss_1v2.n243 4.2505
R6275 vss_1v2.n4133 vss_1v2.n244 4.2505
R6276 vss_1v2.n4133 vss_1v2.n245 4.2505
R6277 vss_1v2.n4133 vss_1v2.n246 4.2505
R6278 vss_1v2.n4133 vss_1v2.n247 4.2505
R6279 vss_1v2.n4133 vss_1v2.n248 4.2505
R6280 vss_1v2.n4133 vss_1v2.n249 4.2505
R6281 vss_1v2.n4133 vss_1v2.n250 4.2505
R6282 vss_1v2.n4133 vss_1v2.n251 4.2505
R6283 vss_1v2.n4133 vss_1v2.n252 4.2505
R6284 vss_1v2.n4133 vss_1v2.n253 4.2505
R6285 vss_1v2.n4133 vss_1v2.n254 4.2505
R6286 vss_1v2.n4133 vss_1v2.n255 4.2505
R6287 vss_1v2.n4133 vss_1v2.n256 4.2505
R6288 vss_1v2.n4133 vss_1v2.n257 4.2505
R6289 vss_1v2.n4133 vss_1v2.n258 4.2505
R6290 vss_1v2.n4133 vss_1v2.n259 4.2505
R6291 vss_1v2.n4133 vss_1v2.n1007 4.2505
R6292 vss_1v2.n4133 vss_1v2.n4 4.2505
R6293 vss_1v2.n462 vss_1v2.n311 4.2505
R6294 vss_1v2.n3833 vss_1v2.n2511 4.25028
R6295 vss_1v2.n3537 vss_1v2.n2861 4.25011
R6296 vss_1v2.n3327 vss_1v2.n462 4.24994
R6297 vss_1v2.n3345 vss_1v2.n308 4.24983
R6298 vss_1v2.n3505 vss_1v2.n3504 4.24983
R6299 vss_1v2.n3588 vss_1v2.n2659 4.24981
R6300 vss_1v2.n3149 vss_1v2.n2991 4.24981
R6301 vss_1v2.n3493 vss_1v2.n3492 4.24981
R6302 vss_1v2.n3566 vss_1v2.n3565 4.24981
R6303 vss_1v2.n4027 vss_1v2.n1968 4.24981
R6304 vss_1v2.n3138 vss_1v2.n3129 4.23768
R6305 vss_1v2.n3090 vss_1v2.n3089 4.23768
R6306 vss_1v2.n2821 vss_1v2.n2682 4.23768
R6307 vss_1v2.n2848 vss_1v2.n1981 4.23768
R6308 vss_1v2.t46 vss_1v2.n47 2.80983
R6309 vss_1v2.t46 vss_1v2.n73 2.80983
R6310 vss_1v2.n48 vss_1v2.n18 1.65822
R6311 vss_1v2.n4129 vss_1v2.n1880 4.22987
R6312 vss_1v2.t315 vss_1v2.n650 4.13073
R6313 vss_1v2.n2949 vss_1v2.n1968 4.07388
R6314 vss_1v2.n3568 vss_1v2.n1968 4.07369
R6315 vss_1v2.t303 vss_1v2.n337 3.94787
R6316 vss_1v2.n4133 vss_1v2.n1266 3.91475
R6317 vss_1v2.n4133 vss_1v2.n1265 3.91475
R6318 vss_1v2.n4133 vss_1v2.n1264 3.91475
R6319 vss_1v2.n4133 vss_1v2.n1263 3.91475
R6320 vss_1v2.n4133 vss_1v2.n1262 3.91475
R6321 vss_1v2.n4133 vss_1v2.n1261 3.91475
R6322 vss_1v2.n4133 vss_1v2.n1260 3.91475
R6323 vss_1v2.n4133 vss_1v2.n1259 3.91475
R6324 vss_1v2.n4133 vss_1v2.n1258 3.91475
R6325 vss_1v2.n4133 vss_1v2.n1257 3.91475
R6326 vss_1v2.n4133 vss_1v2.n1256 3.91475
R6327 vss_1v2.n4133 vss_1v2.n1255 3.91475
R6328 vss_1v2.n4133 vss_1v2.n1254 3.91475
R6329 vss_1v2.n4133 vss_1v2.n1253 3.91475
R6330 vss_1v2.n4133 vss_1v2.n1252 3.91475
R6331 vss_1v2.n4133 vss_1v2.n1229 3.91475
R6332 vss_1v2.n4133 vss_1v2.n1230 3.91475
R6333 vss_1v2.n4133 vss_1v2.n1231 3.91475
R6334 vss_1v2.n4133 vss_1v2.n1232 3.91475
R6335 vss_1v2.n4133 vss_1v2.n1233 3.91475
R6336 vss_1v2.n4133 vss_1v2.n1234 3.91475
R6337 vss_1v2.n4133 vss_1v2.n1235 3.91475
R6338 vss_1v2.n4133 vss_1v2.n1236 3.91475
R6339 vss_1v2.n4133 vss_1v2.n1237 3.91475
R6340 vss_1v2.n4133 vss_1v2.n1238 3.91475
R6341 vss_1v2.n4133 vss_1v2.n1239 3.91475
R6342 vss_1v2.n4133 vss_1v2.n1240 3.91475
R6343 vss_1v2.n4133 vss_1v2.n1241 3.91475
R6344 vss_1v2.n4133 vss_1v2.n1242 3.91475
R6345 vss_1v2.n4133 vss_1v2.n1243 3.91475
R6346 vss_1v2.n4133 vss_1v2.n1244 3.91475
R6347 vss_1v2.n4133 vss_1v2.n1245 3.91475
R6348 vss_1v2.n4133 vss_1v2.n1246 3.91475
R6349 vss_1v2.n4133 vss_1v2.n1247 3.91475
R6350 vss_1v2.n4133 vss_1v2.n1248 3.91475
R6351 vss_1v2.n4133 vss_1v2.n1249 3.91475
R6352 vss_1v2.n462 vss_1v2.n2801 3.91058
R6353 vss_1v2.n462 vss_1v2.n2798 3.91058
R6354 vss_1v2.n462 vss_1v2.n2795 3.91058
R6355 vss_1v2.n462 vss_1v2.n2792 3.91058
R6356 vss_1v2.n462 vss_1v2.n2789 3.91058
R6357 vss_1v2.n462 vss_1v2.n2786 3.91058
R6358 vss_1v2.n462 vss_1v2.n2783 3.91058
R6359 vss_1v2.n462 vss_1v2.n2780 3.91058
R6360 vss_1v2.n462 vss_1v2.n2777 3.91058
R6361 vss_1v2.n462 vss_1v2.n2774 3.91058
R6362 vss_1v2.n462 vss_1v2.n2771 3.91058
R6363 vss_1v2.n462 vss_1v2.n2768 3.91058
R6364 vss_1v2.n462 vss_1v2.n2699 3.91058
R6365 vss_1v2.n462 vss_1v2.n2765 3.91058
R6366 vss_1v2.n462 vss_1v2.n2762 3.91058
R6367 vss_1v2.n462 vss_1v2.n2759 3.91058
R6368 vss_1v2.n462 vss_1v2.n2756 3.91058
R6369 vss_1v2.n462 vss_1v2.n2753 3.91058
R6370 vss_1v2.n462 vss_1v2.n2750 3.91058
R6371 vss_1v2.n462 vss_1v2.n2747 3.91058
R6372 vss_1v2.n462 vss_1v2.n2744 3.91058
R6373 vss_1v2.n462 vss_1v2.n2741 3.91058
R6374 vss_1v2.n462 vss_1v2.n2738 3.91058
R6375 vss_1v2.n462 vss_1v2.n2735 3.91058
R6376 vss_1v2.n462 vss_1v2.n2732 3.91058
R6377 vss_1v2.n462 vss_1v2.n2729 3.91058
R6378 vss_1v2.n462 vss_1v2.n2726 3.91058
R6379 vss_1v2.n462 vss_1v2.n2723 3.91058
R6380 vss_1v2.n462 vss_1v2.n2720 3.91058
R6381 vss_1v2.n462 vss_1v2.n2717 3.91058
R6382 vss_1v2.n462 vss_1v2.n2714 3.91058
R6383 vss_1v2.n462 vss_1v2.n2711 3.91058
R6384 vss_1v2.n462 vss_1v2.n2708 3.91058
R6385 vss_1v2.n462 vss_1v2.n2705 3.91058
R6386 vss_1v2.n462 vss_1v2.n2702 3.91058
R6387 vss_1v2.t362 vss_1v2.n605 3.90748
R6388 vss_1v2.t274 vss_1v2.n513 3.89534
R6389 vss_1v2.n1313 vss_1v2.t278 3.89534
R6390 vss_1v2.n2509 vss_1v2.n2508 3.85057
R6391 vss_1v2.n3831 vss_1v2.n3830 3.85057
R6392 vss_1v2.n2488 vss_1v2.t289 3.82451
R6393 vss_1v2.n2760 vss_1v2.t299 3.82451
R6394 vss_1v2.n2917 vss_1v2.n2916 3.82451
R6395 vss_1v2.n195 vss_1v2.t324 3.79585
R6396 vss_1v2.n4003 vss_1v2.n2357 3.73734
R6397 vss_1v2.n3538 vss_1v2.n2856 3.70116
R6398 vss_1v2.t17 vss_1v2.n311 3.70116
R6399 vss_1v2.t3 vss_1v2.n316 3.70116
R6400 vss_1v2.n3101 vss_1v2.t170 3.68665
R6401 vss_1v2.t231 vss_1v2.n3419 3.68665
R6402 vss_1v2.t227 vss_1v2.n3407 3.68665
R6403 vss_1v2.n1877 vss_1v2.n713 3.6727
R6404 vss_1v2.t22 vss_1v2.n559 3.65191
R6405 vss_1v2.n223 vss_1v2.t11 3.65191
R6406 vss_1v2.n1333 vss_1v2.t21 3.65191
R6407 vss_1v2.t29 vss_1v2.n509 3.65191
R6408 vss_1v2.n12 vss_1v2.n716 3.64951
R6409 vss_1v2.n12 vss_1v2.n719 3.64951
R6410 vss_1v2.n4129 vss_1v2.n1899 3.64951
R6411 vss_1v2.n4129 vss_1v2.n1896 3.64951
R6412 vss_1v2.t166 vss_1v2.n3102 3.63641
R6413 vss_1v2.n2769 vss_1v2.t1 3.5778
R6414 vss_1v2.n4094 vss_1v2.n164 3.57259
R6415 vss_1v2.t363 vss_1v2.n854 3.46097
R6416 vss_1v2.n3102 vss_1v2.t167 3.43931
R6417 vss_1v2.n3241 vss_1v2.n2526 3.43213
R6418 vss_1v2.n3533 vss_1v2.n81 3.40208
R6419 vss_1v2.n371 vss_1v2.n3809 3.39595
R6420 vss_1v2.t228 vss_1v2.n3407 3.34613
R6421 vss_1v2.n4097 vss_1v2.n721 3.34101
R6422 vss_1v2.n206 vss_1v2.n712 3.34101
R6423 vss_1v2.n218 vss_1v2.n722 3.34101
R6424 vss_1v2.n2493 vss_1v2.t196 3.33109
R6425 vss_1v2.n2928 vss_1v2.n2927 3.33109
R6426 vss_1v2.t171 vss_1v2.n3101 3.32853
R6427 vss_1v2.n3419 vss_1v2.t232 3.32853
R6428 vss_1v2.n2802 vss_1v2.n2523 3.312
R6429 vss_1v2.n3553 vss_1v2.n934 3.20774
R6430 vss_1v2.n3542 vss_1v2.n3541 3.20774
R6431 vss_1v2.t0 vss_1v2.n326 3.20774
R6432 vss_1v2.t11 vss_1v2.n895 3.16506
R6433 vss_1v2.n1323 vss_1v2.t27 3.16506
R6434 vss_1v2.t27 vss_1v2.n519 3.16506
R6435 vss_1v2.n108 vss_1v2.t33 3.12608
R6436 vss_1v2.n2462 vss_1v2.t17 3.08438
R6437 vss_1v2.n2742 vss_1v2.t0 3.08438
R6438 vss_1v2.n2921 vss_1v2.n2920 3.08438
R6439 vss_1v2.t310 vss_1v2.n608 3.01445
R6440 vss_1v2.t73 vss_1v2.n581 3.01445
R6441 vss_1v2.t289 vss_1v2.n277 2.96103
R6442 vss_1v2.n4087 vss_1v2.n263 2.9201
R6443 vss_1v2.n199 vss_1v2.t35 2.90283
R6444 vss_1v2.n216 vss_1v2.n1904 2.88806
R6445 vss_1v2.n217 vss_1v2.n1895 2.88806
R6446 vss_1v2.n1884 vss_1v2.n707 2.87597
R6447 vss_1v2.n1886 vss_1v2.n706 2.87597
R6448 vss_1v2.n1887 vss_1v2.n705 2.87597
R6449 vss_1v2.n1888 vss_1v2.n704 2.87597
R6450 vss_1v2.n3829 vss_1v2.n1901 2.87597
R6451 vss_1v2.n1885 vss_1v2.n725 2.87597
R6452 vss_1v2.n3829 vss_1v2.n1900 2.8755
R6453 vss_1v2.n1889 vss_1v2.n704 2.8755
R6454 vss_1v2.n1888 vss_1v2.n705 2.8755
R6455 vss_1v2.n1887 vss_1v2.n706 2.8755
R6456 vss_1v2.n1886 vss_1v2.n725 2.8755
R6457 vss_1v2.n1885 vss_1v2.n707 2.8755
R6458 vss_1v2.n1884 vss_1v2.n708 2.8755
R6459 vss_1v2.n1882 vss_1v2.n713 2.8755
R6460 vss_1v2.n4119 vss_1v2.n1879 2.84475
R6461 vss_1v2.n396 vss_1v2.n4022 2.83383
R6462 vss_1v2.n3842 vss_1v2.n2443 2.83383
R6463 vss_1v2.n4081 vss_1v2.n4088 2.83383
R6464 vss_1v2.n4129 vss_1v2.n1869 2.83337
R6465 vss_1v2.n3590 vss_1v2.n457 2.83199
R6466 vss_1v2.n3330 vss_1v2.n303 2.83199
R6467 vss_1v2.n4025 vss_1v2.n1968 2.83153
R6468 vss_1v2.t46 vss_1v2.n28 0.541268
R6469 vss_1v2.n3841 vss_1v2.n3840 2.77482
R6470 vss_1v2.n213 vss_1v2.n1893 2.77482
R6471 vss_1v2.n214 vss_1v2.n1905 2.77482
R6472 vss_1v2.t178 vss_1v2.n2887 2.7505
R6473 vss_1v2.t1 vss_1v2.n336 2.71432
R6474 vss_1v2.n247 vss_1v2.t22 2.6782
R6475 vss_1v2.t21 vss_1v2.n529 2.6782
R6476 vss_1v2.n1314 vss_1v2.t29 2.6782
R6477 vss_1v2.n3112 vss_1v2.n3108 2.65272
R6478 vss_1v2.n3197 vss_1v2.n1222 2.65256
R6479 vss_1v2.n2712 vss_1v2.t3 2.59096
R6480 vss_1v2.n4107 vss_1v2.n4104 2.5855
R6481 vss_1v2.n208 vss_1v2.n703 2.56794
R6482 vss_1v2.n85 vss_1v2.n727 2.56794
R6483 vss_1v2.n86 vss_1v2.n701 2.56794
R6484 vss_1v2.n87 vss_1v2.n729 2.56794
R6485 vss_1v2.n88 vss_1v2.n699 2.56794
R6486 vss_1v2.n90 vss_1v2.n697 2.56794
R6487 vss_1v2.n91 vss_1v2.n733 2.56794
R6488 vss_1v2.n93 vss_1v2.n735 2.56794
R6489 vss_1v2.n94 vss_1v2.n693 2.56794
R6490 vss_1v2.n95 vss_1v2.n737 2.56794
R6491 vss_1v2.n96 vss_1v2.n691 2.56794
R6492 vss_1v2.n97 vss_1v2.n739 2.56794
R6493 vss_1v2.n98 vss_1v2.n689 2.56794
R6494 vss_1v2.n99 vss_1v2.n741 2.56794
R6495 vss_1v2.n100 vss_1v2.n687 2.56794
R6496 vss_1v2.n101 vss_1v2.n742 2.56794
R6497 vss_1v2.n102 vss_1v2.n686 2.56794
R6498 vss_1v2.n103 vss_1v2.n744 2.56794
R6499 vss_1v2.n104 vss_1v2.n684 2.56794
R6500 vss_1v2.n105 vss_1v2.n746 2.56794
R6501 vss_1v2.n106 vss_1v2.n682 2.56794
R6502 vss_1v2.n107 vss_1v2.n748 2.56794
R6503 vss_1v2.n108 vss_1v2.n680 2.56794
R6504 vss_1v2.n109 vss_1v2.n750 2.56794
R6505 vss_1v2.n110 vss_1v2.n678 2.56794
R6506 vss_1v2.n111 vss_1v2.n752 2.56794
R6507 vss_1v2.n112 vss_1v2.n676 2.56794
R6508 vss_1v2.n113 vss_1v2.n754 2.56794
R6509 vss_1v2.n114 vss_1v2.n674 2.56794
R6510 vss_1v2.n115 vss_1v2.n756 2.56794
R6511 vss_1v2.n116 vss_1v2.n672 2.56794
R6512 vss_1v2.n117 vss_1v2.n758 2.56794
R6513 vss_1v2.n118 vss_1v2.n671 2.56794
R6514 vss_1v2.n119 vss_1v2.n759 2.56794
R6515 vss_1v2.n120 vss_1v2.n669 2.56794
R6516 vss_1v2.n121 vss_1v2.n761 2.56794
R6517 vss_1v2.n122 vss_1v2.n667 2.56794
R6518 vss_1v2.n123 vss_1v2.n763 2.56794
R6519 vss_1v2.n124 vss_1v2.n665 2.56794
R6520 vss_1v2.n125 vss_1v2.n764 2.56794
R6521 vss_1v2.n126 vss_1v2.n664 2.56794
R6522 vss_1v2.n127 vss_1v2.n766 2.56794
R6523 vss_1v2.n128 vss_1v2.n662 2.56794
R6524 vss_1v2.n129 vss_1v2.n768 2.56794
R6525 vss_1v2.n130 vss_1v2.n660 2.56794
R6526 vss_1v2.n131 vss_1v2.n770 2.56794
R6527 vss_1v2.n132 vss_1v2.n658 2.56794
R6528 vss_1v2.n133 vss_1v2.n772 2.56794
R6529 vss_1v2.n134 vss_1v2.n656 2.56794
R6530 vss_1v2.n135 vss_1v2.n774 2.56794
R6531 vss_1v2.n136 vss_1v2.n654 2.56794
R6532 vss_1v2.n137 vss_1v2.n776 2.56794
R6533 vss_1v2.n138 vss_1v2.n652 2.56794
R6534 vss_1v2.n139 vss_1v2.n778 2.56794
R6535 vss_1v2.n140 vss_1v2.n650 2.56794
R6536 vss_1v2.n141 vss_1v2.n780 2.56794
R6537 vss_1v2.n142 vss_1v2.n649 2.56794
R6538 vss_1v2.n143 vss_1v2.n781 2.56794
R6539 vss_1v2.n144 vss_1v2.n647 2.56794
R6540 vss_1v2.n145 vss_1v2.n783 2.56794
R6541 vss_1v2.n146 vss_1v2.n645 2.56794
R6542 vss_1v2.n147 vss_1v2.n785 2.56794
R6543 vss_1v2.n148 vss_1v2.n643 2.56794
R6544 vss_1v2.n61 vss_1v2.n786 2.56794
R6545 vss_1v2.n62 vss_1v2.n642 2.56794
R6546 vss_1v2.n60 vss_1v2.n788 2.56794
R6547 vss_1v2.n63 vss_1v2.n640 2.56794
R6548 vss_1v2.n59 vss_1v2.n790 2.56794
R6549 vss_1v2.t35 vss_1v2.n850 2.56794
R6550 vss_1v2.t175 vss_1v2.n484 2.55113
R6551 vss_1v2.t163 vss_1v2.t162 2.51599
R6552 vss_1v2.n3124 vss_1v2.n3123 2.50306
R6553 vss_1v2.n3534 vss_1v2.n3533 2.46761
R6554 vss_1v2.n3530 vss_1v2.n1990 2.46761
R6555 vss_1v2.n3527 vss_1v2.n1989 2.46761
R6556 vss_1v2.t299 vss_1v2.n332 2.46761
R6557 vss_1v2.n371 vss_1v2.n2526 2.45717
R6558 vss_1v2.n92 vss_1v2.t70 2.45631
R6559 vss_1v2.n168 vss_1v2.t310 2.45631
R6560 vss_1v2.n198 vss_1v2.t73 2.45631
R6561 vss_1v2.t270 vss_1v2.n555 2.43477
R6562 vss_1v2.n1317 vss_1v2.t274 2.43477
R6563 vss_1v2.t278 vss_1v2.n921 2.43477
R6564 vss_1v2.n265 vss_1v2.n4077 2.43278
R6565 vss_1v2.t46 vss_1v2.n20 0.254513
R6566 vss_1v2.n12 vss_1v2.n720 2.42713
R6567 vss_1v2.n4016 vss_1v2.n1896 2.40698
R6568 vss_1v2.n2279 vss_1v2.n1899 2.40698
R6569 vss_1v2.n4128 vss_1v2.n716 2.40698
R6570 vss_1v2.n4123 vss_1v2.n719 2.40698
R6571 vss_1v2.n3107 vss_1v2.n3106 2.40137
R6572 vss_1v2.n2483 vss_1v2.t293 2.34425
R6573 vss_1v2.n2772 vss_1v2.t303 2.34425
R6574 vss_1v2.n3203 vss_1v2.n3202 2.27819
R6575 vss_1v2.n1630 vss_1v2.n1622 2.23754
R6576 vss_1v2.n3780 vss_1v2.n3779 2.23754
R6577 vss_1v2.n3524 vss_1v2.n1991 2.22089
R6578 vss_1v2.n1993 vss_1v2.n1988 2.22089
R6579 vss_1v2.n4021 vss_1v2.n1992 2.22089
R6580 vss_1v2.t24 vss_1v2.n539 2.19135
R6581 vss_1v2.n3569 vss_1v2.n2693 2.126
R6582 vss_1v2.n2000 vss_1v2.n1968 2.12596
R6583 vss_1v2.n4132 vss_1v2.n260 2.1255
R6584 vss_1v2.n58 vss_1v2.n637 2.12143
R6585 vss_1v2.n65 vss_1v2.n794 2.12143
R6586 vss_1v2.n57 vss_1v2.n635 2.12143
R6587 vss_1v2.n66 vss_1v2.n795 2.12143
R6588 vss_1v2.n56 vss_1v2.n634 2.12143
R6589 vss_1v2.n67 vss_1v2.n797 2.12143
R6590 vss_1v2.n55 vss_1v2.n632 2.12143
R6591 vss_1v2.n68 vss_1v2.n799 2.12143
R6592 vss_1v2.n54 vss_1v2.n630 2.12143
R6593 vss_1v2.n69 vss_1v2.n801 2.12143
R6594 vss_1v2.n53 vss_1v2.n629 2.12143
R6595 vss_1v2.n70 vss_1v2.n802 2.12143
R6596 vss_1v2.n149 vss_1v2.n627 2.12143
R6597 vss_1v2.n150 vss_1v2.n804 2.12143
R6598 vss_1v2.n152 vss_1v2.n806 2.12143
R6599 vss_1v2.n153 vss_1v2.n623 2.12143
R6600 vss_1v2.n154 vss_1v2.n808 2.12143
R6601 vss_1v2.n155 vss_1v2.n621 2.12143
R6602 vss_1v2.n156 vss_1v2.n810 2.12143
R6603 vss_1v2.n157 vss_1v2.n619 2.12143
R6604 vss_1v2.n158 vss_1v2.n812 2.12143
R6605 vss_1v2.n159 vss_1v2.n617 2.12143
R6606 vss_1v2.n160 vss_1v2.n814 2.12143
R6607 vss_1v2.n161 vss_1v2.n615 2.12143
R6608 vss_1v2.n162 vss_1v2.n816 2.12143
R6609 vss_1v2.n163 vss_1v2.n613 2.12143
R6610 vss_1v2.n164 vss_1v2.n817 2.12143
R6611 vss_1v2.n165 vss_1v2.n612 2.12143
R6612 vss_1v2.n166 vss_1v2.n819 2.12143
R6613 vss_1v2.n167 vss_1v2.n610 2.12143
R6614 vss_1v2.n168 vss_1v2.n821 2.12143
R6615 vss_1v2.n169 vss_1v2.n608 2.12143
R6616 vss_1v2.n170 vss_1v2.n823 2.12143
R6617 vss_1v2.n171 vss_1v2.n607 2.12143
R6618 vss_1v2.n172 vss_1v2.n824 2.12143
R6619 vss_1v2.n173 vss_1v2.n605 2.12143
R6620 vss_1v2.n174 vss_1v2.n826 2.12143
R6621 vss_1v2.n175 vss_1v2.n603 2.12143
R6622 vss_1v2.n176 vss_1v2.n828 2.12143
R6623 vss_1v2.n177 vss_1v2.n601 2.12143
R6624 vss_1v2.n178 vss_1v2.n830 2.12143
R6625 vss_1v2.n179 vss_1v2.n599 2.12143
R6626 vss_1v2.n181 vss_1v2.n597 2.12143
R6627 vss_1v2.n182 vss_1v2.n834 2.12143
R6628 vss_1v2.n183 vss_1v2.n595 2.12143
R6629 vss_1v2.n185 vss_1v2.n593 2.12143
R6630 vss_1v2.n186 vss_1v2.n838 2.12143
R6631 vss_1v2.n187 vss_1v2.n591 2.12143
R6632 vss_1v2.n189 vss_1v2.n590 2.12143
R6633 vss_1v2.n190 vss_1v2.n841 2.12143
R6634 vss_1v2.n191 vss_1v2.n588 2.12143
R6635 vss_1v2.n192 vss_1v2.n843 2.12143
R6636 vss_1v2.n193 vss_1v2.n586 2.12143
R6637 vss_1v2.n194 vss_1v2.n845 2.12143
R6638 vss_1v2.n195 vss_1v2.n585 2.12143
R6639 vss_1v2.n196 vss_1v2.n846 2.12143
R6640 vss_1v2.n197 vss_1v2.n583 2.12143
R6641 vss_1v2.n198 vss_1v2.n848 2.12143
R6642 vss_1v2.n199 vss_1v2.n581 2.12143
R6643 vss_1v2.n200 vss_1v2.n850 2.12143
R6644 vss_1v2.n201 vss_1v2.n579 2.12143
R6645 vss_1v2.n202 vss_1v2.n852 2.12143
R6646 vss_1v2.n203 vss_1v2.n577 2.12143
R6647 vss_1v2.n204 vss_1v2.n854 2.12143
R6648 vss_1v2.n4129 vss_1v2.n1882 2.11603
R6649 vss_1v2.n4129 vss_1v2.n1883 2.11603
R6650 vss_1v2.n4129 vss_1v2.n1884 2.11603
R6651 vss_1v2.n4129 vss_1v2.n1885 2.11603
R6652 vss_1v2.n4129 vss_1v2.n1886 2.11603
R6653 vss_1v2.n4129 vss_1v2.n1887 2.11603
R6654 vss_1v2.n4129 vss_1v2.n1888 2.11603
R6655 vss_1v2.n4129 vss_1v2.n1889 2.11603
R6656 vss_1v2.n4129 vss_1v2.n1892 2.11603
R6657 vss_1v2.n4129 vss_1v2.n1903 2.11603
R6658 vss_1v2.n4129 vss_1v2.n1902 2.11603
R6659 vss_1v2.n4129 vss_1v2.n1901 2.11603
R6660 vss_1v2.n4129 vss_1v2.n1900 2.11603
R6661 vss_1v2.n3833 vss_1v2.n3829 2.11588
R6662 vss_1v2.n12 vss_1v2.n704 2.11588
R6663 vss_1v2.n12 vss_1v2.n705 2.11588
R6664 vss_1v2.n12 vss_1v2.n706 2.11588
R6665 vss_1v2.n12 vss_1v2.n725 2.11588
R6666 vss_1v2.n12 vss_1v2.n707 2.11588
R6667 vss_1v2.n12 vss_1v2.n708 2.11588
R6668 vss_1v2.n12 vss_1v2.n713 2.11588
R6669 vss_1v2.n2467 vss_1v2.t2 2.09754
R6670 vss_1v2.n2462 vss_1v2.n312 2.09754
R6671 vss_1v2.n4043 vss_1v2.n4042 2.05059
R6672 vss_1v2.n3021 vss_1v2.n3020 2.05059
R6673 vss_1v2.n2893 vss_1v2.n484 2.0135
R6674 vss_1v2.n188 vss_1v2.t40 2.0098
R6675 vss_1v2.n203 vss_1v2.t363 2.0098
R6676 vss_1v2.n215 vss_1v2.t38 1.98216
R6677 vss_1v2.n4096 vss_1v2.n710 1.98216
R6678 vss_1v2.n4100 vss_1v2.n724 1.98216
R6679 vss_1v2.n4099 vss_1v2.n709 1.98216
R6680 vss_1v2.n4098 vss_1v2.n1910 1.98216
R6681 vss_1v2.n74 vss_1v2.n77 0.981655
R6682 vss_1v2.n266 vss_1v2.n4086 1.98201
R6683 vss_1v2.t196 vss_1v2.t285 1.97418
R6684 vss_1v2.n259 vss_1v2.n860 1.94792
R6685 vss_1v2.n258 vss_1v2.n569 1.94792
R6686 vss_1v2.n257 vss_1v2.n862 1.94792
R6687 vss_1v2.n256 vss_1v2.n567 1.94792
R6688 vss_1v2.n255 vss_1v2.n864 1.94792
R6689 vss_1v2.n253 vss_1v2.n866 1.94792
R6690 vss_1v2.n252 vss_1v2.n563 1.94792
R6691 vss_1v2.n251 vss_1v2.t247 1.94792
R6692 vss_1v2.n251 vss_1v2.n868 1.94792
R6693 vss_1v2.n250 vss_1v2.n561 1.94792
R6694 vss_1v2.n249 vss_1v2.n870 1.94792
R6695 vss_1v2.n248 vss_1v2.n559 1.94792
R6696 vss_1v2.n247 vss_1v2.n871 1.94792
R6697 vss_1v2.n222 vss_1v2.n895 1.94792
R6698 vss_1v2.t66 vss_1v2.n731 1.89817
R6699 vss_1v2.t33 vss_1v2.n750 1.89817
R6700 vss_1v2.n4094 vss_1v2.n612 1.89817
R6701 vss_1v2.t9 vss_1v2.n832 1.89817
R6702 vss_1v2.n72 vss_1v2.n4098 1.88939
R6703 vss_1v2.n72 vss_1v2.n4097 1.88939
R6704 vss_1v2.n4100 vss_1v2.n710 1.86892
R6705 vss_1v2.n4099 vss_1v2.n724 1.86892
R6706 vss_1v2.n4098 vss_1v2.n709 1.86892
R6707 vss_1v2.n3527 vss_1v2.t331 1.85083
R6708 vss_1v2.n1996 vss_1v2.n297 1.85083
R6709 vss_1v2.t62 vss_1v2.n2923 1.85083
R6710 vss_1v2.t46 vss_1v2.n24 1.65876
R6711 vss_1v2.n1268 vss_1v2.n1267 1.84188
R6712 vss_1v2.n3202 vss_1v2.n3201 1.8265
R6713 vss_1v2.n4081 vss_1v2.n262 1.78905
R6714 vss_1v2.n16 vss_1v2.n15 0.980846
R6715 vss_1v2.n3547 vss_1v2.t57 1.72747
R6716 vss_1v2.n3548 vss_1v2.n3547 1.72747
R6717 vss_1v2.t55 vss_1v2.n2925 1.72747
R6718 vss_1v2.n3545 vss_1v2.t59 1.72747
R6719 vss_1v2.t19 vss_1v2.n549 1.70449
R6720 vss_1v2.n12 vss_1v2.n792 1.69784
R6721 vss_1v2.n1273 vss_1v2.n1268 1.69027
R6722 vss_1v2.t324 vss_1v2.n846 1.67492
R6723 vss_1v2.n3125 vss_1v2.n3124 1.65812
R6724 vss_1v2.n2802 vss_1v2.n348 1.6565
R6725 vss_1v2.n3537 vss_1v2.n2857 1.62923
R6726 vss_1v2.n4046 vss_1v2.n4045 1.61977
R6727 vss_1v2.n3200 vss_1v2.n3193 1.61149
R6728 vss_1v2.n1267 vss_1v2.n1222 1.60558
R6729 vss_1v2.n3509 vss_1v2.n3506 1.60412
R6730 vss_1v2.n2665 vss_1v2.n267 1.60412
R6731 vss_1v2.n2692 vss_1v2.n310 1.60412
R6732 vss_1v2.n2498 vss_1v2.n268 1.60412
R6733 vss_1v2.n2497 vss_1v2.n269 1.60412
R6734 vss_1v2.n2495 vss_1v2.n271 1.60412
R6735 vss_1v2.n2494 vss_1v2.n272 1.60412
R6736 vss_1v2.n2493 vss_1v2.n273 1.60412
R6737 vss_1v2.n2492 vss_1v2.n274 1.60412
R6738 vss_1v2.n2491 vss_1v2.n275 1.60412
R6739 vss_1v2.n2490 vss_1v2.n276 1.60412
R6740 vss_1v2.n2489 vss_1v2.n277 1.60412
R6741 vss_1v2.n2488 vss_1v2.n278 1.60412
R6742 vss_1v2.n2487 vss_1v2.n279 1.60412
R6743 vss_1v2.n2485 vss_1v2.n281 1.60412
R6744 vss_1v2.n2484 vss_1v2.n282 1.60412
R6745 vss_1v2.n2483 vss_1v2.n283 1.60412
R6746 vss_1v2.n2482 vss_1v2.n284 1.60412
R6747 vss_1v2.n2481 vss_1v2.n285 1.60412
R6748 vss_1v2.n2480 vss_1v2.n286 1.60412
R6749 vss_1v2.n2479 vss_1v2.n287 1.60412
R6750 vss_1v2.n2478 vss_1v2.n288 1.60412
R6751 vss_1v2.n2477 vss_1v2.t5 1.60412
R6752 vss_1v2.n2477 vss_1v2.n289 1.60412
R6753 vss_1v2.n2476 vss_1v2.n290 1.60412
R6754 vss_1v2.n2475 vss_1v2.n291 1.60412
R6755 vss_1v2.n2474 vss_1v2.n292 1.60412
R6756 vss_1v2.n2473 vss_1v2.n293 1.60412
R6757 vss_1v2.n2472 vss_1v2.n294 1.60412
R6758 vss_1v2.n2471 vss_1v2.n295 1.60412
R6759 vss_1v2.n2470 vss_1v2.n296 1.60412
R6760 vss_1v2.n2469 vss_1v2.n297 1.60412
R6761 vss_1v2.n2468 vss_1v2.n298 1.60412
R6762 vss_1v2.n2467 vss_1v2.n299 1.60412
R6763 vss_1v2.n2466 vss_1v2.n300 1.60412
R6764 vss_1v2.n2465 vss_1v2.n301 1.60412
R6765 vss_1v2.n2464 vss_1v2.n302 1.60412
R6766 vss_1v2.n2463 vss_1v2.n311 1.60412
R6767 vss_1v2.n2925 vss_1v2.n2924 1.60412
R6768 vss_1v2.n260 vss_1v2.n1337 1.59167
R6769 vss_1v2.n3123 vss_1v2.n3122 1.57391
R6770 vss_1v2.n172 vss_1v2.t362 1.56329
R6771 vss_1v2.t246 vss_1v2.n436 1.4987
R6772 vss_1v2.n33 vss_1v2.n16 0.630969
R6773 vss_1v2.t202 vss_1v2.n270 1.48076
R6774 vss_1v2.t285 vss_1v2.n272 1.48076
R6775 vss_1v2.t206 vss_1v2.n345 1.48076
R6776 vss_1v2.n2804 vss_1v2.n348 1.48076
R6777 vss_1v2.n256 vss_1v2.t149 1.46106
R6778 vss_1v2.n254 vss_1v2.t264 1.46106
R6779 vss_1v2.t153 vss_1v2.n565 1.46106
R6780 vss_1v2.n245 vss_1v2.n557 1.46106
R6781 vss_1v2.n244 vss_1v2.n873 1.46106
R6782 vss_1v2.n243 vss_1v2.n555 1.46106
R6783 vss_1v2.n242 vss_1v2.n875 1.46106
R6784 vss_1v2.n241 vss_1v2.n553 1.46106
R6785 vss_1v2.n240 vss_1v2.n877 1.46106
R6786 vss_1v2.n239 vss_1v2.n551 1.46106
R6787 vss_1v2.n238 vss_1v2.n879 1.46106
R6788 vss_1v2.n237 vss_1v2.n549 1.46106
R6789 vss_1v2.n236 vss_1v2.n881 1.46106
R6790 vss_1v2.n235 vss_1v2.n547 1.46106
R6791 vss_1v2.n234 vss_1v2.n883 1.46106
R6792 vss_1v2.n233 vss_1v2.n545 1.46106
R6793 vss_1v2.n232 vss_1v2.n885 1.46106
R6794 vss_1v2.n231 vss_1v2.n543 1.46106
R6795 vss_1v2.n230 vss_1v2.n887 1.46106
R6796 vss_1v2.n229 vss_1v2.n541 1.46106
R6797 vss_1v2.n228 vss_1v2.n889 1.46106
R6798 vss_1v2.n227 vss_1v2.n539 1.46106
R6799 vss_1v2.n226 vss_1v2.n891 1.46106
R6800 vss_1v2.n225 vss_1v2.n537 1.46106
R6801 vss_1v2.n224 vss_1v2.n893 1.46106
R6802 vss_1v2.n223 vss_1v2.n535 1.46106
R6803 vss_1v2.n1305 vss_1v2.t97 1.46106
R6804 vss_1v2.t101 vss_1v2.n503 1.46106
R6805 vss_1v2.n3126 vss_1v2.n3023 1.4562
R6806 vss_1v2.n4044 vss_1v2.n4033 1.4536
R6807 vss_1v2.n3126 vss_1v2.n2901 1.4536
R6808 vss_1v2.t46 vss_1v2.n8 0.283553
R6809 vss_1v2.n4131 vss_1v2.n856 1.45166
R6810 vss_1v2.n1882 vss_1v2.n721 1.43857
R6811 vss_1v2.n1883 vss_1v2.n723 1.43857
R6812 vss_1v2.n1889 vss_1v2.n726 1.43857
R6813 vss_1v2.n3840 vss_1v2.n1892 1.43857
R6814 vss_1v2.n2508 vss_1v2.n1903 1.43857
R6815 vss_1v2.n3830 vss_1v2.n1902 1.43857
R6816 vss_1v2.n2357 vss_1v2.n1900 1.43857
R6817 vss_1v2.n3831 vss_1v2.n1901 1.4381
R6818 vss_1v2.n2509 vss_1v2.n1902 1.4381
R6819 vss_1v2.n2506 vss_1v2.n1903 1.4381
R6820 vss_1v2.n2913 vss_1v2.n1892 1.4381
R6821 vss_1v2.n1883 vss_1v2.n711 1.4381
R6822 vss_1v2.n1910 vss_1v2.n708 1.4379
R6823 vss_1v2.n4044 vss_1v2.n1966 1.42502
R6824 vss_1v2.n2997 vss_1v2.n16 2.15566
R6825 vss_1v2.n3023 vss_1v2.n3022 1.39596
R6826 vss_1v2.n4033 vss_1v2.n4032 1.37388
R6827 vss_1v2.n3489 vss_1v2.n2901 1.37388
R6828 vss_1v2.n1977 vss_1v2.n1966 1.36906
R6829 vss_1v2.n3203 vss_1v2.n3187 1.35908
R6830 vss_1v2.n2787 vss_1v2.t210 1.35741
R6831 vss_1v2.n3096 vss_1v2.n3095 1.35717
R6832 vss_1v2.n4078 vss_1v2.n265 1.35055
R6833 vss_1v2.n3414 vss_1v2.n3413 1.34669
R6834 vss_1v2.n3126 vss_1v2.n3125 1.32645
R6835 vss_1v2.n3424 vss_1v2.n3423 1.32574
R6836 vss_1v2.n4045 vss_1v2.n4044 1.29798
R6837 vss_1v2.n4044 vss_1v2.n4043 1.29307
R6838 vss_1v2.n3126 vss_1v2.n3021 1.29307
R6839 vss_1v2.t18 vss_1v2.t297 1.28844
R6840 vss_1v2.t286 vss_1v2.t284 1.28813
R6841 vss_1v2.t317 vss_1v2.n625 1.22841
R6842 vss_1v2.n4132 vss_1v2.n858 1.21764
R6843 vss_1v2.n1010 vss_1v2.n571 1.21764
R6844 vss_1v2.n3176 vss_1v2.n43 1.216
R6845 vss_1v2.n4096 vss_1v2.t54 1.18949
R6846 vss_1v2.n3199 vss_1v2.n3198 1.17383
R6847 vss_1v2.n2675 vss_1v2.n1968 1.16829
R6848 vss_1v2.n4110 vss_1v2.n1958 1.16145
R6849 vss_1v2.n4109 vss_1v2.t132 1.15979
R6850 vss_1v2.n3208 vss_1v2.n3170 1.12778
R6851 vss_1v2.n3185 vss_1v2.n3184 1.12525
R6852 vss_1v2.n184 vss_1v2.t361 1.11678
R6853 vss_1v2.n2487 vss_1v2.t4 1.1107
R6854 vss_1v2.n2486 vss_1v2.t291 1.1107
R6855 vss_1v2.n3841 vss_1v2.n1893 1.07626
R6856 vss_1v2.n213 vss_1v2.n1905 1.07626
R6857 vss_1v2.n214 vss_1v2.n1894 1.07626
R6858 vss_1v2.n4086 vss_1v2.n4078 1.06568
R6859 vss_1v2.n3075 vss_1v2.n3074 1.02831
R6860 vss_1v2.n3194 vss_1v2.n3187 1.01494
R6861 vss_1v2.t318 vss_1v2.n834 1.00515
R6862 vss_1v2.t361 vss_1v2.n836 1.00515
R6863 vss_1v2.n3192 vss_1v2.t246 0.999472
R6864 vss_1v2.t295 vss_1v2.n285 0.987342
R6865 vss_1v2.n3193 vss_1v2.n3192 0.986272
R6866 vss_1v2.t266 vss_1v2.n870 0.97421
R6867 vss_1v2.n241 vss_1v2.t272 0.97421
R6868 vss_1v2.n215 vss_1v2.n1904 0.963018
R6869 vss_1v2.n216 vss_1v2.n1895 0.963018
R6870 vss_1v2.n2506 vss_1v2.n217 0.963018
R6871 vss_1v2.n3494 vss_1v2.n2887 0.963
R6872 vss_1v2.n4091 vss_1v2.n4089 0.948834
R6873 vss_1v2.n3072 vss_1v2.n3071 0.948759
R6874 vss_1v2.n9 vss_1v2.n4089 0.939109
R6875 vss_1v2.n1878 vss_1v2.n716 0.914088
R6876 vss_1v2.t38 vss_1v2.n1894 0.9064
R6877 vss_1v2.n265 vss_1v2.n262 0.89696
R6878 vss_1v2.n139 vss_1v2.t315 0.893523
R6879 vss_1v2.n151 vss_1v2.t317 0.893523
R6880 vss_1v2.n4069 vss_1v2.n4068 0.883188
R6881 vss_1v2.t85 vss_1v2.t71 0.883188
R6882 vss_1v2.t334 vss_1v2.t316 0.878788
R6883 vss_1v2.n3122 vss_1v2.n3028 0.842239
R6884 vss_1v2.n82 vss_1v2.t58 0.792715
R6885 vss_1v2.n1880 vss_1v2.n719 0.831661
R6886 vss_1v2.n3210 vss_1v2.n15 0.826573
R6887 vss_1v2.n34 vss_1v2.n16 0.668869
R6888 vss_1v2.n3112 vss_1v2.n16 0.386778
R6889 vss_1v2.n2285 vss_1v2.n1899 0.802992
R6890 vss_1v2.n2449 vss_1v2.n1896 0.802992
R6891 vss_1v2.n41 vss_1v2.n4095 0.00207608
R6892 vss_1v2.n2281 vss_1v2.n1881 0.796306
R6893 vss_1v2.n3197 vss_1v2.n3196 0.783595
R6894 vss_1v2.t309 vss_1v2.n843 0.781895
R6895 vss_1v2.n355 vss_1v2.n35 0.00629202
R6896 vss_1v2.t46 vss_1v2.n10 0.314229
R6897 vss_1v2.n3074 vss_1v2.n3058 0.760187
R6898 vss_1v2.n3070 vss_1v2.n3064 0.756561
R6899 vss_1v2.n485 vss_1v2.n484 0.752167
R6900 vss_1v2.n4134 vss_1v2.n1220 0.740632
R6901 vss_1v2.n3455 vss_1v2.n2957 0.740632
R6902 vss_1v2.n3482 vss_1v2.n2525 0.740632
R6903 vss_1v2.n1890 vss_1v2.n726 0.736543
R6904 vss_1v2.n2 vss_1v2.n0 0.676405
R6905 vss_1v2.n4101 vss_1v2.n42 0.00109216
R6906 vss_1v2.n19 vss_1v2.t46 0.405754
R6907 vss_1v2.n31 vss_1v2.n2 0.465124
R6908 vss_1v2.t208 vss_1v2.n2947 0.72925
R6909 vss_1v2.t223 vss_1v2.n3451 0.72925
R6910 vss_1v2.t239 vss_1v2.n3426 0.72925
R6911 vss_1v2.n3411 vss_1v2.t197 0.72925
R6912 vss_1v2.n3403 vss_1v2.t236 0.72925
R6913 vss_1v2.t263 vss_1v2.n3351 0.72925
R6914 vss_1v2.n3226 vss_1v2.t200 0.72925
R6915 vss_1v2.t244 vss_1v2.n3217 0.72925
R6916 vss_1v2.n3179 vss_1v2.t192 0.72925
R6917 vss_1v2.n3131 vss_1v2.t187 0.72925
R6918 vss_1v2.n3087 vss_1v2.t178 0.72925
R6919 vss_1v2.n3041 vss_1v2.t158 0.72925
R6920 vss_1v2.n3031 vss_1v2.t163 0.72925
R6921 vss_1v2.n2996 vss_1v2.t180 0.72925
R6922 vss_1v2.n2988 vss_1v2.t241 0.72925
R6923 vss_1v2.t256 vss_1v2.n2976 0.72925
R6924 vss_1v2.t226 vss_1v2.n2884 0.72925
R6925 vss_1v2.n2842 vss_1v2.t155 0.72925
R6926 vss_1v2.n2818 vss_1v2.t99 0.72925
R6927 vss_1v2.n2811 vss_1v2.t217 0.72925
R6928 vss_1v2.n1983 vss_1v2.t203 0.72925
R6929 vss_1v2.t151 vss_1v2.n1 0.145005
R6930 vss_1v2.n3064 vss_1v2.n3063 0.71401
R6931 vss_1v2.n2526 vss_1v2.t18 0.711275
R6932 vss_1v2.t316 vss_1v2.t46 2.57003
R6933 vss_1v2.n2662 vss_1v2.t286 0.706634
R6934 vss_1v2.n396 vss_1v2.n395 0.697861
R6935 vss_1v2.n6 vss_1v2.n1303 0.671463
R6936 vss_1v2.n425 vss_1v2.n3346 0.698626
R6937 vss_1v2.n352 vss_1v2.n2900 0.697861
R6938 vss_1v2.n2879 vss_1v2.n2868 0.697861
R6939 vss_1v2.n1975 vss_1v2.n408 0.697861
R6940 vss_1v2.n4069 vss_1v2.n10 2.34623
R6941 vss_1v2.n2801 vss_1v2.n2800 0.681847
R6942 vss_1v2.n2798 vss_1v2.n2797 0.681847
R6943 vss_1v2.n2795 vss_1v2.n2794 0.681847
R6944 vss_1v2.n2792 vss_1v2.n2791 0.681847
R6945 vss_1v2.n2789 vss_1v2.n2788 0.681847
R6946 vss_1v2.n2786 vss_1v2.n2785 0.681847
R6947 vss_1v2.n2783 vss_1v2.n2782 0.681847
R6948 vss_1v2.n2780 vss_1v2.n2779 0.681847
R6949 vss_1v2.n2777 vss_1v2.n2776 0.681847
R6950 vss_1v2.n2774 vss_1v2.n2773 0.681847
R6951 vss_1v2.n2771 vss_1v2.n2770 0.681847
R6952 vss_1v2.n2768 vss_1v2.n2767 0.681847
R6953 vss_1v2.n2699 vss_1v2.t301 0.681847
R6954 vss_1v2.n2765 vss_1v2.n2764 0.681847
R6955 vss_1v2.n2762 vss_1v2.n2761 0.681847
R6956 vss_1v2.n2759 vss_1v2.n2758 0.681847
R6957 vss_1v2.n2756 vss_1v2.n2755 0.681847
R6958 vss_1v2.n2753 vss_1v2.n2752 0.681847
R6959 vss_1v2.n2750 vss_1v2.n2749 0.681847
R6960 vss_1v2.n2747 vss_1v2.n2746 0.681847
R6961 vss_1v2.n2744 vss_1v2.n2743 0.681847
R6962 vss_1v2.n2741 vss_1v2.n2740 0.681847
R6963 vss_1v2.n2738 vss_1v2.n2737 0.681847
R6964 vss_1v2.n2735 vss_1v2.n2734 0.681847
R6965 vss_1v2.n2732 vss_1v2.n2731 0.681847
R6966 vss_1v2.n2729 vss_1v2.n2728 0.681847
R6967 vss_1v2.n2726 vss_1v2.n2725 0.681847
R6968 vss_1v2.n2723 vss_1v2.n2722 0.681847
R6969 vss_1v2.n2720 vss_1v2.n2719 0.681847
R6970 vss_1v2.n2717 vss_1v2.n2716 0.681847
R6971 vss_1v2.n2714 vss_1v2.n2713 0.681847
R6972 vss_1v2.n2711 vss_1v2.n2710 0.681847
R6973 vss_1v2.n2708 vss_1v2.n2707 0.681847
R6974 vss_1v2.n2705 vss_1v2.n2704 0.681847
R6975 vss_1v2.n2702 vss_1v2.n2701 0.681847
R6976 vss_1v2.n2702 vss_1v2.n313 0.681847
R6977 vss_1v2.n2705 vss_1v2.n314 0.681847
R6978 vss_1v2.n2708 vss_1v2.n315 0.681847
R6979 vss_1v2.n2711 vss_1v2.n316 0.681847
R6980 vss_1v2.n2714 vss_1v2.n317 0.681847
R6981 vss_1v2.n2717 vss_1v2.n318 0.681847
R6982 vss_1v2.n2720 vss_1v2.n319 0.681847
R6983 vss_1v2.n2723 vss_1v2.n320 0.681847
R6984 vss_1v2.n2726 vss_1v2.n321 0.681847
R6985 vss_1v2.n2729 vss_1v2.n322 0.681847
R6986 vss_1v2.n2732 vss_1v2.n323 0.681847
R6987 vss_1v2.n2735 vss_1v2.n324 0.681847
R6988 vss_1v2.n2738 vss_1v2.n325 0.681847
R6989 vss_1v2.n2741 vss_1v2.n326 0.681847
R6990 vss_1v2.n2744 vss_1v2.n327 0.681847
R6991 vss_1v2.n2747 vss_1v2.n328 0.681847
R6992 vss_1v2.n2750 vss_1v2.n329 0.681847
R6993 vss_1v2.n2753 vss_1v2.n330 0.681847
R6994 vss_1v2.n2756 vss_1v2.n331 0.681847
R6995 vss_1v2.n2759 vss_1v2.n332 0.681847
R6996 vss_1v2.n2762 vss_1v2.n333 0.681847
R6997 vss_1v2.n2765 vss_1v2.n334 0.681847
R6998 vss_1v2.n2768 vss_1v2.n336 0.681847
R6999 vss_1v2.n2771 vss_1v2.n337 0.681847
R7000 vss_1v2.n2774 vss_1v2.n338 0.681847
R7001 vss_1v2.n2777 vss_1v2.n339 0.681847
R7002 vss_1v2.n2780 vss_1v2.n340 0.681847
R7003 vss_1v2.n2783 vss_1v2.n341 0.681847
R7004 vss_1v2.n2786 vss_1v2.n342 0.681847
R7005 vss_1v2.n2789 vss_1v2.n343 0.681847
R7006 vss_1v2.n2792 vss_1v2.n344 0.681847
R7007 vss_1v2.n2795 vss_1v2.n345 0.681847
R7008 vss_1v2.n2798 vss_1v2.n346 0.681847
R7009 vss_1v2.n2801 vss_1v2.n347 0.681847
R7010 vss_1v2.n2699 vss_1v2.n335 0.681847
R7011 vss_1v2.t54 vss_1v2.n723 0.679925
R7012 vss_1v2.n3070 vss_1v2.n3065 0.678877
R7013 vss_1v2.n1229 vss_1v2.n954 0.673504
R7014 vss_1v2.n1230 vss_1v2.n1217 0.673504
R7015 vss_1v2.n1231 vss_1v2.n1058 0.673504
R7016 vss_1v2.n1232 vss_1v2.n1056 0.673504
R7017 vss_1v2.n1233 vss_1v2.n964 0.673504
R7018 vss_1v2.n1234 vss_1v2.t276 0.673504
R7019 vss_1v2.n1235 vss_1v2.n1050 0.673504
R7020 vss_1v2.n1236 vss_1v2.n969 0.673504
R7021 vss_1v2.n1237 vss_1v2.n1046 0.673504
R7022 vss_1v2.n1238 vss_1v2.n971 0.673504
R7023 vss_1v2.n1239 vss_1v2.n1044 0.673504
R7024 vss_1v2.n1240 vss_1v2.n1042 0.673504
R7025 vss_1v2.n1241 vss_1v2.n975 0.673504
R7026 vss_1v2.n1242 vss_1v2.n1040 0.673504
R7027 vss_1v2.n1243 vss_1v2.n977 0.673504
R7028 vss_1v2.n1244 vss_1v2.n1036 0.673504
R7029 vss_1v2.n1245 vss_1v2.n981 0.673504
R7030 vss_1v2.n1246 vss_1v2.n1034 0.673504
R7031 vss_1v2.n1247 vss_1v2.n985 0.673504
R7032 vss_1v2.n1248 vss_1v2.n1030 0.673504
R7033 vss_1v2.n1249 vss_1v2.n987 0.673504
R7034 vss_1v2.n1299 vss_1v2.n1266 0.673504
R7035 vss_1v2.n1305 vss_1v2.n1265 0.673504
R7036 vss_1v2.n1306 vss_1v2.n1264 0.673504
R7037 vss_1v2.n1307 vss_1v2.n1263 0.673504
R7038 vss_1v2.n1309 vss_1v2.n1262 0.673504
R7039 vss_1v2.n1311 vss_1v2.n1261 0.673504
R7040 vss_1v2.n1312 vss_1v2.n1260 0.673504
R7041 vss_1v2.n1314 vss_1v2.n1259 0.673504
R7042 vss_1v2.n1316 vss_1v2.n1258 0.673504
R7043 vss_1v2.n1317 vss_1v2.n1257 0.673504
R7044 vss_1v2.n1322 vss_1v2.n1256 0.673504
R7045 vss_1v2.n1327 vss_1v2.n1255 0.673504
R7046 vss_1v2.n1328 vss_1v2.n1254 0.673504
R7047 vss_1v2.n1332 vss_1v2.n1253 0.673504
R7048 vss_1v2.n1333 vss_1v2.n1252 0.673504
R7049 vss_1v2.n1336 vss_1v2.n1249 0.673504
R7050 vss_1v2.n1335 vss_1v2.n1248 0.673504
R7051 vss_1v2.n1334 vss_1v2.n1247 0.673504
R7052 vss_1v2.n1252 vss_1v2.n1032 0.673504
R7053 vss_1v2.n1253 vss_1v2.n983 0.673504
R7054 vss_1v2.n1331 vss_1v2.n1246 0.673504
R7055 vss_1v2.n1330 vss_1v2.n1245 0.673504
R7056 vss_1v2.n1329 vss_1v2.n1244 0.673504
R7057 vss_1v2.n1254 vss_1v2.n979 0.673504
R7058 vss_1v2.n1255 vss_1v2.n1038 0.673504
R7059 vss_1v2.n1326 vss_1v2.n1243 0.673504
R7060 vss_1v2.n1325 vss_1v2.n1242 0.673504
R7061 vss_1v2.n1324 vss_1v2.n1241 0.673504
R7062 vss_1v2.n1323 vss_1v2.n1240 0.673504
R7063 vss_1v2.n1256 vss_1v2.n973 0.673504
R7064 vss_1v2.n1321 vss_1v2.n1239 0.673504
R7065 vss_1v2.n1320 vss_1v2.n1238 0.673504
R7066 vss_1v2.n1319 vss_1v2.n1237 0.673504
R7067 vss_1v2.n1318 vss_1v2.n1236 0.673504
R7068 vss_1v2.n1257 vss_1v2.n1048 0.673504
R7069 vss_1v2.n1258 vss_1v2.n967 0.673504
R7070 vss_1v2.n1315 vss_1v2.n1235 0.673504
R7071 vss_1v2.n1259 vss_1v2.n1052 0.673504
R7072 vss_1v2.n1313 vss_1v2.n1233 0.673504
R7073 vss_1v2.n1260 vss_1v2.n1054 0.673504
R7074 vss_1v2.n1261 vss_1v2.n962 0.673504
R7075 vss_1v2.n1310 vss_1v2.n1232 0.673504
R7076 vss_1v2.n1262 vss_1v2.n960 0.673504
R7077 vss_1v2.n1308 vss_1v2.n1231 0.673504
R7078 vss_1v2.n1263 vss_1v2.n958 0.673504
R7079 vss_1v2.n1264 vss_1v2.n1215 0.673504
R7080 vss_1v2.n1265 vss_1v2.n956 0.673504
R7081 vss_1v2.n1304 vss_1v2.n1230 0.673504
R7082 vss_1v2.n1300 vss_1v2.n1229 0.673504
R7083 vss_1v2.n1266 vss_1v2.n1218 0.673504
R7084 vss_1v2.n221 vss_1v2.n1234 0.673504
R7085 vss_1v2.n3211 vss_1v2.n3210 0.670863
R7086 vss_1v2.n89 vss_1v2.t66 0.670267
R7087 vss_1v2.n176 vss_1v2.t6 0.670267
R7088 vss_1v2.n201 vss_1v2.t80 0.670267
R7089 vss_1v2.n395 vss_1v2.n4019 0.668521
R7090 vss_1v2.n2117 vss_1v2.n1975 0.668521
R7091 vss_1v2.n2912 vss_1v2.n2900 0.668521
R7092 vss_1v2.n2872 vss_1v2.n2868 0.668521
R7093 vss_1v2.n3200 vss_1v2.n3199 0.66106
R7094 vss_1v2.n3195 vss_1v2.n3193 0.6583
R7095 vss_1v2.n3073 vss_1v2.n3072 0.652643
R7096 vss_1v2.n82 vss_1v2.n1998 0.736046
R7097 vss_1v2.n2701 vss_1v2.n2700 0.617276
R7098 vss_1v2.n2704 vss_1v2.n2703 0.617276
R7099 vss_1v2.n2707 vss_1v2.n2706 0.617276
R7100 vss_1v2.n2710 vss_1v2.n2709 0.617276
R7101 vss_1v2.n2713 vss_1v2.n2712 0.617276
R7102 vss_1v2.n2716 vss_1v2.n2715 0.617276
R7103 vss_1v2.n2719 vss_1v2.n2718 0.617276
R7104 vss_1v2.n2722 vss_1v2.n2721 0.617276
R7105 vss_1v2.n2725 vss_1v2.n2724 0.617276
R7106 vss_1v2.n2728 vss_1v2.n2727 0.617276
R7107 vss_1v2.n2731 vss_1v2.n2730 0.617276
R7108 vss_1v2.n2734 vss_1v2.n2733 0.617276
R7109 vss_1v2.n2737 vss_1v2.n2736 0.617276
R7110 vss_1v2.n2740 vss_1v2.n2739 0.617276
R7111 vss_1v2.n2743 vss_1v2.n2742 0.617276
R7112 vss_1v2.n2746 vss_1v2.n2745 0.617276
R7113 vss_1v2.n2749 vss_1v2.n2748 0.617276
R7114 vss_1v2.n2752 vss_1v2.n2751 0.617276
R7115 vss_1v2.n2755 vss_1v2.n2754 0.617276
R7116 vss_1v2.n2758 vss_1v2.n2757 0.617276
R7117 vss_1v2.n2761 vss_1v2.n2760 0.617276
R7118 vss_1v2.n2764 vss_1v2.n2763 0.617276
R7119 vss_1v2.t301 vss_1v2.n2698 0.617276
R7120 vss_1v2.n2767 vss_1v2.n2766 0.617276
R7121 vss_1v2.n2770 vss_1v2.n2769 0.617276
R7122 vss_1v2.n2773 vss_1v2.n2772 0.617276
R7123 vss_1v2.n2776 vss_1v2.n2775 0.617276
R7124 vss_1v2.n2779 vss_1v2.n2778 0.617276
R7125 vss_1v2.n2782 vss_1v2.n2781 0.617276
R7126 vss_1v2.n2785 vss_1v2.n2784 0.617276
R7127 vss_1v2.n2788 vss_1v2.n2787 0.617276
R7128 vss_1v2.n2791 vss_1v2.n2790 0.617276
R7129 vss_1v2.n2794 vss_1v2.n2793 0.617276
R7130 vss_1v2.n2797 vss_1v2.n2796 0.617276
R7131 vss_1v2.n2800 vss_1v2.n2799 0.617276
R7132 vss_1v2.n2804 vss_1v2.n2803 0.617276
R7133 vss_1v2.n2957 vss_1v2.n2956 0.617276
R7134 vss_1v2.n3365 vss_1v2.n2525 0.617276
R7135 vss_1v2.n3178 vss_1v2.n3177 0.59979
R7136 vss_1v2.n4120 vss_1v2.n4118 0.583441
R7137 vss_1v2.n3184 vss_1v2.n3179 0.578
R7138 vss_1v2.n2444 vss_1v2.n77 0.691208
R7139 vss_1v2.n4086 vss_1v2.n4085 0.555761
R7140 vss_1v2.n4080 vss_1v2.n4078 0.551865
R7141 vss_1v2.n1337 vss_1v2.n1007 0.547653
R7142 vss_1v2.n4080 vss_1v2.t47 0.533687
R7143 vss_1v2.n2844 vss_1v2.n2843 0.518157
R7144 vss_1v2.n3130 vss_1v2.n3137 0.518157
R7145 vss_1v2.n1963 vss_1v2.n1962 0.518157
R7146 vss_1v2.n1984 vss_1v2.n1982 0.518157
R7147 vss_1v2.n2812 vss_1v2.n2810 0.518157
R7148 vss_1v2.n2819 vss_1v2.n2817 0.518157
R7149 vss_1v2.n2975 vss_1v2.n2974 0.518157
R7150 vss_1v2.n2989 vss_1v2.n2987 0.518157
R7151 vss_1v2.n2998 vss_1v2.n2995 0.518157
R7152 vss_1v2.n3049 vss_1v2.n3042 0.518157
R7153 vss_1v2.n3221 vss_1v2.n3220 0.518157
R7154 vss_1v2.n3227 vss_1v2.n3225 0.518157
R7155 vss_1v2.n3350 vss_1v2.n3349 0.518157
R7156 vss_1v2.n3450 vss_1v2.n3449 0.518157
R7157 vss_1v2.n3459 vss_1v2.n3458 0.518157
R7158 vss_1v2.t207 vss_1v2.n3458 0.518157
R7159 vss_1v2.n3449 vss_1v2.t211 0.518157
R7160 vss_1v2.n3349 vss_1v2.t260 0.518157
R7161 vss_1v2.t189 vss_1v2.n3227 0.518157
R7162 vss_1v2.n3220 vss_1v2.t245 0.518157
R7163 vss_1v2.t185 vss_1v2.n3137 0.518157
R7164 vss_1v2.n3042 vss_1v2.t157 0.518157
R7165 vss_1v2.t181 vss_1v2.n2998 0.518157
R7166 vss_1v2.t242 vss_1v2.n2989 0.518157
R7167 vss_1v2.n2974 vss_1v2.t253 0.518157
R7168 vss_1v2.n2843 vss_1v2.t143 0.518157
R7169 vss_1v2.t98 vss_1v2.n2819 0.518157
R7170 vss_1v2.t218 vss_1v2.n2812 0.518157
R7171 vss_1v2.t204 vss_1v2.n1984 0.518157
R7172 vss_1v2.n1962 vss_1v2.t150 0.518157
R7173 vss_1v2.t191 vss_1v2.n3177 0.517235
R7174 vss_1v2.n4089 vss_1v2.n4088 0.51236
R7175 vss_1v2.n2914 vss_1v2.n2913 0.510069
R7176 vss_1v2.n4097 vss_1v2.n712 0.510069
R7177 vss_1v2.n206 vss_1v2.n722 0.510069
R7178 vss_1v2.n218 vss_1v2.n711 0.510069
R7179 vss_1v2.n4134 vss_1v2.n937 0.493921
R7180 vss_1v2.n3539 vss_1v2.t61 0.493921
R7181 vss_1v2.t291 vss_1v2.n280 0.493921
R7182 vss_1v2.t305 vss_1v2.n340 0.493921
R7183 vss_1v2.n2918 vss_1v2.t64 0.493921
R7184 vss_1v2.t264 vss_1v2.n565 0.487355
R7185 vss_1v2.n246 vss_1v2.t268 0.487355
R7186 vss_1v2.n987 vss_1v2.n533 0.487355
R7187 vss_1v2.n1030 vss_1v2.n897 0.487355
R7188 vss_1v2.n985 vss_1v2.n531 0.487355
R7189 vss_1v2.n1032 vss_1v2.n899 0.487355
R7190 vss_1v2.n983 vss_1v2.n529 0.487355
R7191 vss_1v2.n1034 vss_1v2.n901 0.487355
R7192 vss_1v2.n981 vss_1v2.n527 0.487355
R7193 vss_1v2.n1036 vss_1v2.n903 0.487355
R7194 vss_1v2.n979 vss_1v2.n525 0.487355
R7195 vss_1v2.n1038 vss_1v2.n905 0.487355
R7196 vss_1v2.n977 vss_1v2.n523 0.487355
R7197 vss_1v2.n1040 vss_1v2.n907 0.487355
R7198 vss_1v2.n975 vss_1v2.n521 0.487355
R7199 vss_1v2.n1042 vss_1v2.n909 0.487355
R7200 vss_1v2.n973 vss_1v2.n519 0.487355
R7201 vss_1v2.n1044 vss_1v2.n911 0.487355
R7202 vss_1v2.n971 vss_1v2.n517 0.487355
R7203 vss_1v2.t248 vss_1v2.n913 0.487355
R7204 vss_1v2.n1046 vss_1v2.n913 0.487355
R7205 vss_1v2.n969 vss_1v2.n515 0.487355
R7206 vss_1v2.n1048 vss_1v2.n915 0.487355
R7207 vss_1v2.n967 vss_1v2.n513 0.487355
R7208 vss_1v2.n1050 vss_1v2.n917 0.487355
R7209 vss_1v2.t276 vss_1v2.n511 0.487355
R7210 vss_1v2.n1052 vss_1v2.n919 0.487355
R7211 vss_1v2.n964 vss_1v2.n509 0.487355
R7212 vss_1v2.n1054 vss_1v2.n921 0.487355
R7213 vss_1v2.n962 vss_1v2.n507 0.487355
R7214 vss_1v2.n1056 vss_1v2.n923 0.487355
R7215 vss_1v2.n1310 vss_1v2.t280 0.487355
R7216 vss_1v2.n960 vss_1v2.n505 0.487355
R7217 vss_1v2.n1058 vss_1v2.n925 0.487355
R7218 vss_1v2.n958 vss_1v2.n503 0.487355
R7219 vss_1v2.n1215 vss_1v2.n927 0.487355
R7220 vss_1v2.n956 vss_1v2.n501 0.487355
R7221 vss_1v2.n1217 vss_1v2.n929 0.487355
R7222 vss_1v2.n954 vss_1v2.n499 0.487355
R7223 vss_1v2.n1218 vss_1v2.n931 0.487355
R7224 vss_1v2.n949 vss_1v2.n497 0.487355
R7225 vss_1v2.n1964 vss_1v2.n1220 0.480504
R7226 vss_1v2.n3483 vss_1v2.n3482 0.480504
R7227 vss_1v2.n4119 vss_1v2.n1881 0.479142
R7228 vss_1v2.n3558 vss_1v2.n1297 0.474965
R7229 vss_1v2.n4132 vss_1v2.n1296 0.4743
R7230 vss_1v2.n3558 vss_1v2.n1226 0.4743
R7231 vss_1v2.n4120 vss_1v2.n4119 0.46374
R7232 vss_1v2.n3102 vss_1v2.n3082 0.462731
R7233 vss_1v2.n3095 vss_1v2.n3085 0.461452
R7234 vss_1v2.n3506 vss_1v2.n2675 0.458629
R7235 vss_1v2.t136 vss_1v2.n3174 0.457
R7236 vss_1v2.n29 vss_1v2.n44 0.119609
R7237 vss_1v2.n3201 vss_1v2.n3193 0.4295
R7238 vss_1v2.n20 vss_1v2.t47 0.377032
R7239 vss_1v2.n4113 vss_1v2.t68 0.419875
R7240 vss_1v2.n4060 vss_1v2.t92 0.419875
R7241 vss_1v2.t105 vss_1v2.n4054 0.419875
R7242 vss_1v2.n3173 vss_1v2.t136 0.419875
R7243 vss_1v2.n1961 vss_1v2.t139 0.419875
R7244 vss_1v2.n1954 vss_1v2.t83 0.419875
R7245 vss_1v2.n1945 vss_1v2.t108 0.419875
R7246 vss_1v2.n441 vss_1v2.t95 0.419875
R7247 vss_1v2.n357 vss_1v2.t121 0.419875
R7248 vss_1v2.n1918 vss_1v2.t130 0.419875
R7249 vss_1v2.n1267 vss_1v2.n1228 0.419373
R7250 vss_1v2.n3003 vss_1v2.n2994 0.416939
R7251 vss_1v2.n3183 vss_1v2.n43 0.416939
R7252 vss_1v2.n3030 vss_1v2.n3113 0.416939
R7253 vss_1v2.n3058 vss_1v2.n3050 0.416939
R7254 vss_1v2.n3040 vss_1v2.n50 0.416939
R7255 vss_1v2.n4046 vss_1v2.n83 0.208147
R7256 vss_1v2.n3014 vss_1v2.n209 0.567297
R7257 vss_1v2.n3208 vss_1v2.n49 0.206435
R7258 vss_1v2.n3113 vss_1v2.n34 0.0336943
R7259 vss_1v2.n1269 vss_1v2.n1228 0.397649
R7260 vss_1v2.n483 vss_1v2.n2888 0.3965
R7261 vss_1v2.n1969 vss_1v2.n1967 0.3855
R7262 vss_1v2.n1267 vss_1v2.n1221 0.382572
R7263 vss_1v2.n4056 vss_1v2.n4055 0.380162
R7264 vss_1v2.n1917 vss_1v2.n1916 0.380162
R7265 vss_1v2.n1931 vss_1v2.n1930 0.380162
R7266 vss_1v2.n1938 vss_1v2.n1937 0.380162
R7267 vss_1v2.n1944 vss_1v2.n1943 0.380162
R7268 vss_1v2.n1956 vss_1v2.n1955 0.380162
R7269 vss_1v2.n1960 vss_1v2.n1959 0.380162
R7270 vss_1v2.n4059 vss_1v2.n4058 0.380162
R7271 vss_1v2.n4115 vss_1v2.n4114 0.380162
R7272 vss_1v2.n4114 vss_1v2.t67 0.380162
R7273 vss_1v2.t91 vss_1v2.n4059 0.380162
R7274 vss_1v2.n4055 vss_1v2.t78 0.380162
R7275 vss_1v2.t138 vss_1v2.n1960 0.380162
R7276 vss_1v2.n1955 vss_1v2.t82 0.380162
R7277 vss_1v2.t76 vss_1v2.n1943 0.380162
R7278 vss_1v2.t94 vss_1v2.n1937 0.380162
R7279 vss_1v2.t120 vss_1v2.n1930 0.380162
R7280 vss_1v2.t129 vss_1v2.n1916 0.380162
R7281 vss_1v2.n2894 vss_1v2.n2893 0.3745
R7282 vss_1v2.n2894 vss_1v2.n2888 0.3745
R7283 vss_1v2.n2491 vss_1v2.t287 0.370566
R7284 vss_1v2.n2751 vss_1v2.t298 0.370566
R7285 vss_1v2.n2919 vss_1v2.n2918 0.370566
R7286 vss_1v2.n4042 vss_1v2.n4041 0.367439
R7287 vss_1v2.n3020 vss_1v2.n3019 0.367439
R7288 vss_1v2.n3003 vss_1v2.n2996 0.367439
R7289 vss_1v2.t180 vss_1v2.n2997 0.367439
R7290 vss_1v2.t192 vss_1v2.n3183 0.367439
R7291 vss_1v2.n3031 vss_1v2.n3030 0.367439
R7292 vss_1v2.n3050 vss_1v2.t158 0.367439
R7293 vss_1v2.n3041 vss_1v2.n3040 0.367439
R7294 vss_1v2.n4129 vss_1v2.n1853 0.366807
R7295 vss_1v2.t162 vss_1v2.n3029 0.364875
R7296 vss_1v2.n3094 vss_1v2.t175 0.364875
R7297 vss_1v2.n2949 vss_1v2.n349 0.356252
R7298 vss_1v2.n3455 vss_1v2.n2949 0.355981
R7299 vss_1v2.n3569 vss_1v2.n3568 0.355626
R7300 vss_1v2.n3568 vss_1v2.n267 0.355626
R7301 vss_1v2.n3127 vss_1v2.n2902 0.3505
R7302 vss_1v2.n3242 vss_1v2.n3241 0.340633
R7303 vss_1v2.n2845 vss_1v2.t155 0.304833
R7304 vss_1v2.n2820 vss_1v2.n2818 0.304833
R7305 vss_1v2.t99 vss_1v2.n2686 0.304833
R7306 vss_1v2.n3087 vss_1v2.n3086 0.304833
R7307 vss_1v2.t187 vss_1v2.n3132 0.304833
R7308 vss_1v2.n3141 vss_1v2.n3131 0.304833
R7309 vss_1v2.n3228 vss_1v2.n3226 0.304833
R7310 vss_1v2.n3237 vss_1v2.t200 0.304833
R7311 vss_1v2.n3106 vss_1v2.n3080 0.287457
R7312 vss_1v2.n3103 vss_1v2.n3082 0.287457
R7313 vss_1v2.t46 vss_1v2.n9 0.278
R7314 vss_1v2.n3069 vss_1v2.n3067 0.2755
R7315 vss_1v2.n3101 vss_1v2.n3100 0.259111
R7316 vss_1v2.n3419 vss_1v2.n3406 0.259111
R7317 vss_1v2.n3417 vss_1v2.n3407 0.259111
R7318 vss_1v2.n3207 vss_1v2.n3206 0.259
R7319 vss_1v2.n3207 vss_1v2.t136 0.259
R7320 vss_1v2.n3318 vss_1v2.n937 0.247211
R7321 vss_1v2.n3541 vss_1v2.t60 0.247211
R7322 vss_1v2.n3539 vss_1v2.n2855 0.247211
R7323 vss_1v2.t63 vss_1v2.n2921 0.247211
R7324 vss_1v2.n950 vss_1v2.n497 0.243927
R7325 vss_1v2.n3179 vss_1v2.n3178 0.2425
R7326 vss_1v2.n3484 vss_1v2.n3483 0.240752
R7327 vss_1v2.n1964 vss_1v2.n1223 0.240752
R7328 vss_1v2.n2842 vss_1v2.n1980 0.238833
R7329 vss_1v2.n3197 vss_1v2.n3194 0.238833
R7330 vss_1v2.n2 vss_1v2.n1 0.0482326
R7331 vss_1v2.n4057 vss_1v2.n4054 0.238833
R7332 vss_1v2.n4063 vss_1v2.n4062 0.238833
R7333 vss_1v2.n4061 vss_1v2.n4053 0.238833
R7334 vss_1v2.n27 vss_1v2.n4074 0.252457
R7335 vss_1v2.n4049 vss_1v2.n1840 0.238833
R7336 vss_1v2.n4118 vss_1v2.t92 0.238833
R7337 vss_1v2.n36 vss_1v2.n4060 0.238833
R7338 vss_1v2.n1957 vss_1v2.t83 0.238833
R7339 vss_1v2.n1954 vss_1v2.n1953 0.238833
R7340 vss_1v2.n4116 vss_1v2.t68 0.238833
R7341 vss_1v2.n4113 vss_1v2.n28 0.253023
R7342 vss_1v2.n4102 vss_1v2.n1961 0.238833
R7343 vss_1v2.t130 vss_1v2.n1921 0.238833
R7344 vss_1v2.n1922 vss_1v2.n1918 0.238833
R7345 vss_1v2.t121 vss_1v2.n1934 0.238833
R7346 vss_1v2.n360 vss_1v2.n357 0.238833
R7347 vss_1v2.t95 vss_1v2.n1940 0.238833
R7348 vss_1v2.n442 vss_1v2.n441 0.238833
R7349 vss_1v2.t108 vss_1v2.n363 0.238833
R7350 vss_1v2.n1947 vss_1v2.n1945 0.238833
R7351 vss_1v2.n3478 vss_1v2.n2947 0.238833
R7352 vss_1v2.n3470 vss_1v2.t208 0.238833
R7353 vss_1v2.n3451 vss_1v2.n3448 0.238833
R7354 vss_1v2.n377 vss_1v2.t223 0.238833
R7355 vss_1v2.n3426 vss_1v2.n3402 0.238833
R7356 vss_1v2.n373 vss_1v2.t239 0.238833
R7357 vss_1v2.n485 vss_1v2.t226 0.238833
R7358 vss_1v2.n3500 vss_1v2.n2884 0.238833
R7359 vss_1v2.n2976 vss_1v2.n2973 0.238833
R7360 vss_1v2.n2977 vss_1v2.t256 0.238833
R7361 vss_1v2.n3351 vss_1v2.n3347 0.238833
R7362 vss_1v2.n437 vss_1v2.t263 0.238833
R7363 vss_1v2.n4023 vss_1v2.n1983 0.238833
R7364 vss_1v2.n4026 vss_1v2.t203 0.238833
R7365 vss_1v2.n2813 vss_1v2.n2811 0.238833
R7366 vss_1v2.n3575 vss_1v2.t217 0.238833
R7367 vss_1v2.n3150 vss_1v2.n2988 0.238833
R7368 vss_1v2.n3156 vss_1v2.t241 0.238833
R7369 vss_1v2.n3340 vss_1v2.n3217 0.238833
R7370 vss_1v2.n3335 vss_1v2.t244 0.238833
R7371 vss_1v2.n1297 vss_1v2.n1227 0.237972
R7372 vss_1v2.n1226 vss_1v2.n949 0.23765
R7373 vss_1v2.n1296 vss_1v2.n4 0.23765
R7374 vss_1v2.n4104 vss_1v2.t139 0.237
R7375 vss_1v2.n10 vss_1v2.n21 0.310719
R7376 vss_1v2.t178 vss_1v2.n484 0.23425
R7377 vss_1v2.n3117 vss_1v2.n3113 0.232167
R7378 vss_1v2.n4125 vss_1v2.n1853 0.227351
R7379 vss_1v2.n180 vss_1v2.t9 0.223756
R7380 vss_1v2.n25 vss_1v2.n85 0.467314
R7381 vss_1v2.n71 vss_1v2.n1853 0.214561
R7382 vss_1v2.n3097 vss_1v2.n3083 0.2117
R7383 vss_1v2.n3105 vss_1v2.n3081 0.2117
R7384 vss_1v2.n3422 vss_1v2.n3405 0.2117
R7385 vss_1v2.n3418 vss_1v2.n3408 0.2117
R7386 vss_1v2.n4041 vss_1v2.n4040 0.210188
R7387 vss_1v2.n4040 vss_1v2.n4035 0.210188
R7388 vss_1v2.n4039 vss_1v2.n4038 0.210188
R7389 vss_1v2.n4039 vss_1v2.n4037 0.210188
R7390 vss_1v2.n3014 vss_1v2.n3012 0.210188
R7391 vss_1v2.n3019 vss_1v2.n3012 0.210188
R7392 vss_1v2.n3016 vss_1v2.n3015 0.210188
R7393 vss_1v2.n3015 vss_1v2.n3013 0.210188
R7394 vss_1v2.n3202 vss_1v2.n3186 0.210188
R7395 vss_1v2.n3187 vss_1v2.n3186 0.210188
R7396 vss_1v2.n3206 vss_1v2.n3205 0.210188
R7397 vss_1v2.n3205 vss_1v2.n3175 0.210188
R7398 vss_1v2.n3071 vss_1v2.n3033 0.210188
R7399 vss_1v2.n3077 vss_1v2.n3032 0.210188
R7400 vss_1v2.n3072 vss_1v2.n3032 0.210188
R7401 vss_1v2.n4053 vss_1v2.n4051 0.210188
R7402 vss_1v2.n4063 vss_1v2.n4051 0.210188
R7403 vss_1v2.n4067 vss_1v2.n4066 0.210188
R7404 vss_1v2.n4067 vss_1v2.n4052 0.210188
R7405 vss_1v2.n4049 vss_1v2.n4047 0.210188
R7406 vss_1v2.n4074 vss_1v2.n4047 0.210188
R7407 vss_1v2.n4071 vss_1v2.n4070 0.210188
R7408 vss_1v2.n4070 vss_1v2.n4048 0.210188
R7409 vss_1v2.n2983 vss_1v2.n15 0.207434
R7410 vss_1v2.n1952 vss_1v2.n19 0.299242
R7411 vss_1v2.n3585 vss_1v2.n2675 0.204819
R7412 vss_1v2.n12 vss_1v2.n702 0.203911
R7413 vss_1v2.n3199 vss_1v2.n1276 0.190538
R7414 vss_1v2.n3085 vss_1v2.n484 0.186452
R7415 vss_1v2.t71 vss_1v2.n19 2.32629
R7416 vss_1v2.n3198 vss_1v2.n3197 0.177722
R7417 vss_1v2.n4037 vss_1v2.n4036 0.172833
R7418 vss_1v2.n4036 vss_1v2.n4035 0.172833
R7419 vss_1v2.n4038 vss_1v2.n4034 0.172833
R7420 vss_1v2.n4041 vss_1v2.n4034 0.172833
R7421 vss_1v2.n3018 vss_1v2.n3013 0.172833
R7422 vss_1v2.n3019 vss_1v2.n3018 0.172833
R7423 vss_1v2.n3017 vss_1v2.n3016 0.172833
R7424 vss_1v2.n3017 vss_1v2.n3014 0.172833
R7425 vss_1v2.n3172 vss_1v2.n3175 0.172833
R7426 vss_1v2.n3173 vss_1v2.n3172 0.172833
R7427 vss_1v2.n3076 vss_1v2.n3033 0.172833
R7428 vss_1v2.n3077 vss_1v2.n3076 0.172833
R7429 vss_1v2.t105 vss_1v2.t78 0.172833
R7430 vss_1v2.n4056 vss_1v2.n4054 0.172833
R7431 vss_1v2.n4064 vss_1v2.n4052 0.172833
R7432 vss_1v2.n4064 vss_1v2.n4063 0.172833
R7433 vss_1v2.n4066 vss_1v2.n4065 0.172833
R7434 vss_1v2.n4065 vss_1v2.n4053 0.172833
R7435 vss_1v2.n4073 vss_1v2.n4048 0.172833
R7436 vss_1v2.n4074 vss_1v2.n4073 0.172833
R7437 vss_1v2.n4072 vss_1v2.n4071 0.172833
R7438 vss_1v2.n4072 vss_1v2.n4049 0.172833
R7439 vss_1v2.t91 vss_1v2.t92 0.172833
R7440 vss_1v2.n4060 vss_1v2.n4058 0.172833
R7441 vss_1v2.t83 vss_1v2.t82 0.172833
R7442 vss_1v2.n1956 vss_1v2.n1954 0.172833
R7443 vss_1v2.t68 vss_1v2.t67 0.172833
R7444 vss_1v2.n4115 vss_1v2.n4113 0.172833
R7445 vss_1v2.t138 vss_1v2.t139 0.172833
R7446 vss_1v2.n1961 vss_1v2.n1959 0.172833
R7447 vss_1v2.t130 vss_1v2.t129 0.172833
R7448 vss_1v2.n1918 vss_1v2.n1917 0.172833
R7449 vss_1v2.t121 vss_1v2.t120 0.172833
R7450 vss_1v2.n357 vss_1v2.n1931 0.172833
R7451 vss_1v2.t95 vss_1v2.t94 0.172833
R7452 vss_1v2.n441 vss_1v2.n1938 0.172833
R7453 vss_1v2.t108 vss_1v2.t76 0.172833
R7454 vss_1v2.n1945 vss_1v2.n1944 0.172833
R7455 vss_1v2.n3104 vss_1v2.n3080 0.172674
R7456 vss_1v2.n3104 vss_1v2.n3103 0.172674
R7457 vss_1v2.n3058 vss_1v2.n3037 0.168597
R7458 vss_1v2.n3058 vss_1v2.n3054 0.166207
R7459 vss_1v2.n4095 vss_1v2.n1250 0.166207
R7460 vss_1v2.t155 vss_1v2.t143 0.161833
R7461 vss_1v2.n2844 vss_1v2.n2842 0.161833
R7462 vss_1v2.n2818 vss_1v2.n2817 0.161833
R7463 vss_1v2.t98 vss_1v2.t99 0.161833
R7464 vss_1v2.n3094 vss_1v2.n3093 0.161833
R7465 vss_1v2.n3093 vss_1v2.n3087 0.161833
R7466 vss_1v2.n2996 vss_1v2.n2995 0.161833
R7467 vss_1v2.t181 vss_1v2.t180 0.161833
R7468 vss_1v2.t185 vss_1v2.t187 0.161833
R7469 vss_1v2.n3131 vss_1v2.n3130 0.161833
R7470 vss_1v2.n3226 vss_1v2.n3225 0.161833
R7471 vss_1v2.t189 vss_1v2.t200 0.161833
R7472 vss_1v2.t192 vss_1v2.t191 0.161833
R7473 vss_1v2.n3121 vss_1v2.n3031 0.161833
R7474 vss_1v2.n3121 vss_1v2.n3029 0.161833
R7475 vss_1v2.t158 vss_1v2.t157 0.161833
R7476 vss_1v2.n3049 vss_1v2.n3041 0.161833
R7477 vss_1v2.t151 vss_1v2.t150 0.161833
R7478 vss_1v2.n1963 vss_1v2.n1 0.306756
R7479 vss_1v2.n3459 vss_1v2.n2947 0.161833
R7480 vss_1v2.t208 vss_1v2.t207 0.161833
R7481 vss_1v2.n3451 vss_1v2.n3450 0.161833
R7482 vss_1v2.t223 vss_1v2.t211 0.161833
R7483 vss_1v2.n3425 vss_1v2.n3403 0.161833
R7484 vss_1v2.n3426 vss_1v2.n3425 0.161833
R7485 vss_1v2.n3424 vss_1v2.t236 0.161833
R7486 vss_1v2.t236 vss_1v2.n3401 0.161833
R7487 vss_1v2.t239 vss_1v2.n3401 0.161833
R7488 vss_1v2.n3412 vss_1v2.t226 0.161833
R7489 vss_1v2.n3412 vss_1v2.t197 0.161833
R7490 vss_1v2.n3413 vss_1v2.t197 0.161833
R7491 vss_1v2.n3410 vss_1v2.n2884 0.161833
R7492 vss_1v2.n3411 vss_1v2.n3410 0.161833
R7493 vss_1v2.n2976 vss_1v2.n2975 0.161833
R7494 vss_1v2.t256 vss_1v2.t253 0.161833
R7495 vss_1v2.n3351 vss_1v2.n3350 0.161833
R7496 vss_1v2.t263 vss_1v2.t260 0.161833
R7497 vss_1v2.n1983 vss_1v2.n1982 0.161833
R7498 vss_1v2.t204 vss_1v2.t203 0.161833
R7499 vss_1v2.n2811 vss_1v2.n2810 0.161833
R7500 vss_1v2.t218 vss_1v2.t217 0.161833
R7501 vss_1v2.n2988 vss_1v2.n2987 0.161833
R7502 vss_1v2.t242 vss_1v2.t241 0.161833
R7503 vss_1v2.n3221 vss_1v2.n3217 0.161833
R7504 vss_1v2.t244 vss_1v2.t245 0.161833
R7505 vss_1v2.n3100 vss_1v2.n3099 0.157643
R7506 vss_1v2.n3096 vss_1v2.n3084 0.157643
R7507 vss_1v2.n3420 vss_1v2.n3406 0.157643
R7508 vss_1v2.n3423 vss_1v2.n3404 0.157643
R7509 vss_1v2.n3415 vss_1v2.n3414 0.157643
R7510 vss_1v2.n3417 vss_1v2.n3416 0.157643
R7511 vss_1v2.n3074 vss_1v2.n3073 0.153714
R7512 vss_1v2.n4152 vss_1v2.n487 0.141465
R7513 vss_1v2.n3021 vss_1v2.n2828 0.138915
R7514 vss_1v2.n4043 vss_1v2.n1965 0.138915
R7515 vss_1v2.n1337 vss_1v2.n1010 0.137663
R7516 vss_1v2.n3045 vss_1v2.n50 0.137103
R7517 vss_1v2.n3124 vss_1v2.n3024 0.137103
R7518 vss_1v2.n4116 vss_1v2.n24 0.147158
R7519 vss_1v2.n4045 vss_1v2.n1965 0.134578
R7520 vss_1v2.n1855 vss_1v2.n702 0.131277
R7521 vss_1v2.n3125 vss_1v2.n2828 0.129719
R7522 vss_1v2.n3843 vss_1v2.n212 0.125167
R7523 vss_1v2.n2496 vss_1v2.t202 0.123855
R7524 vss_1v2.n2956 vss_1v2.n2523 0.123855
R7525 vss_1v2.n3366 vss_1v2.n3365 0.123855
R7526 vss_1v2.n3007 vss_1v2.n2994 0.122806
R7527 vss_1v2.n2840 vss_1v2.n1981 0.121916
R7528 vss_1v2.n18 vss_1v2.n43 2.21779
R7529 vss_1v2.t171 vss_1v2.n3083 0.1193
R7530 vss_1v2.t232 vss_1v2.n3405 0.1193
R7531 vss_1v2.n3107 vss_1v2.n3028 0.115283
R7532 vss_1v2.n3074 vss_1v2.n210 0.114429
R7533 vss_1v2.n4003 vss_1v2.n2285 0.113737
R7534 vss_1v2.n2449 vss_1v2.n2279 0.113737
R7535 vss_1v2.n4016 vss_1v2.n1897 0.113737
R7536 vss_1v2.n4128 vss_1v2.n715 0.113737
R7537 vss_1v2.n4105 vss_1v2.n702 0.113519
R7538 vss_1v2.t70 vss_1v2.n695 0.112128
R7539 vss_1v2.t40 vss_1v2.n839 0.112128
R7540 vss_1v2.n3326 vss_1v2.n1271 0.1105
R7541 vss_1v2.n3174 vss_1v2.n3176 0.10775
R7542 vss_1v2.t58 vss_1v2.n1995 0.107106
R7543 vss_1v2.n4082 vss_1v2.n4080 0.107106
R7544 vss_1v2.n9 vss_1v2.n4093 0.107106
R7545 vss_1v2.t167 vss_1v2.n3081 0.1017
R7546 vss_1v2.t228 vss_1v2.n3418 0.1017
R7547 vss_1v2.n436 vss_1v2.n435 0.101595
R7548 vss_1v2.n3099 vss_1v2.n3098 0.0947857
R7549 vss_1v2.n3098 vss_1v2.n3084 0.0947857
R7550 vss_1v2.n3421 vss_1v2.n3420 0.0947857
R7551 vss_1v2.n3421 vss_1v2.n3404 0.0947857
R7552 vss_1v2.n3415 vss_1v2.n3409 0.0947857
R7553 vss_1v2.n3416 vss_1v2.n3409 0.0947857
R7554 vss_1v2.n4133 vss_1v2.n1222 0.090346
R7555 vss_1v2.n1273 vss_1v2.n1271 0.0895476
R7556 vss_1v2.n41 vss_1v2.n18 0.586826
R7557 vss_1v2.n1997 vss_1v2.n1995 0.0884851
R7558 vss_1v2.n4083 vss_1v2.n4082 0.0884851
R7559 vss_1v2.n4093 vss_1v2.n4092 0.0884851
R7560 vss_1v2.n1966 vss_1v2.n1965 0.0877282
R7561 vss_1v2.n47 vss_1v2.n36 0.0720235
R7562 vss_1v2.n1953 vss_1v2.n73 0.0720235
R7563 vss_1v2.n1880 vss_1v2.n717 0.0855059
R7564 vss_1v2.n2901 vss_1v2.n2828 0.0854002
R7565 vss_1v2.n4033 vss_1v2.n1965 0.0854002
R7566 vss_1v2.n3023 vss_1v2.n2828 0.0845231
R7567 vss_1v2.n23 vss_1v2.n21 0.111285
R7568 vss_1v2.n3185 vss_1v2.n3176 0.08025
R7569 vss_1v2.n4085 vss_1v2.n4084 0.076766
R7570 vss_1v2.n3022 vss_1v2.n351 0.0763621
R7571 vss_1v2.n3581 vss_1v2.n3580 0.0743571
R7572 vss_1v2.n3133 vss_1v2.n2986 0.0743571
R7573 vss_1v2.n3223 vss_1v2.n3219 0.0743571
R7574 vss_1v2.n2889 vss_1v2.n2886 0.0743571
R7575 vss_1v2.n4129 vss_1v2.n4128 0.0740931
R7576 vss_1v2.n1977 vss_1v2.n406 0.0738333
R7577 vss_1v2.n3555 vss_1v2.n1298 0.0737654
R7578 vss_1v2.n4129 vss_1v2.n1878 0.0722363
R7579 vss_1v2.n4116 vss_1v2.n28 0.130155
R7580 vss_1v2.n3184 vss_1v2.n3170 0.0672112
R7581 vss_1v2.n4026 vss_1v2.n1979 0.0665
R7582 vss_1v2.n2823 vss_1v2.n2813 0.0665
R7583 vss_1v2.n3576 vss_1v2.n3575 0.0665
R7584 vss_1v2.n3500 vss_1v2.n2885 0.0665
R7585 vss_1v2.n3156 vss_1v2.n2985 0.0665
R7586 vss_1v2.n3150 vss_1v2.n2990 0.0665
R7587 vss_1v2.n3340 vss_1v2.n3218 0.0665
R7588 vss_1v2.n3335 vss_1v2.n3222 0.0665
R7589 vss_1v2.n3065 vss_1v2.n1295 0.0643386
R7590 vss_1v2.n2845 vss_1v2.n2841 0.0628333
R7591 vss_1v2.n2841 vss_1v2.n1979 0.0628333
R7592 vss_1v2.n2820 vss_1v2.n2815 0.0628333
R7593 vss_1v2.n2823 vss_1v2.n2815 0.0628333
R7594 vss_1v2.n2686 vss_1v2.n2683 0.0628333
R7595 vss_1v2.n3576 vss_1v2.n2683 0.0628333
R7596 vss_1v2.n3086 vss_1v2.n3088 0.0628333
R7597 vss_1v2.n3088 vss_1v2.n2885 0.0628333
R7598 vss_1v2.n3132 vss_1v2.n2984 0.0628333
R7599 vss_1v2.n2985 vss_1v2.n2984 0.0628333
R7600 vss_1v2.n3142 vss_1v2.n3141 0.0628333
R7601 vss_1v2.n3142 vss_1v2.n2990 0.0628333
R7602 vss_1v2.n3228 vss_1v2.n3224 0.0628333
R7603 vss_1v2.n3224 vss_1v2.n3218 0.0628333
R7604 vss_1v2.n3238 vss_1v2.n3237 0.0628333
R7605 vss_1v2.n3238 vss_1v2.n3222 0.0628333
R7606 vss_1v2.n1629 vss_1v2.n1623 0.0626176
R7607 vss_1v2.n1629 vss_1v2.n1621 0.0626176
R7608 vss_1v2.n1633 vss_1v2.n1621 0.0626176
R7609 vss_1v2.n1633 vss_1v2.n1618 0.0626176
R7610 vss_1v2.n1639 vss_1v2.n1618 0.0626176
R7611 vss_1v2.n1639 vss_1v2.n1616 0.0626176
R7612 vss_1v2.n1643 vss_1v2.n1616 0.0626176
R7613 vss_1v2.n1643 vss_1v2.n1612 0.0626176
R7614 vss_1v2.n1649 vss_1v2.n1612 0.0626176
R7615 vss_1v2.n1649 vss_1v2.n1610 0.0626176
R7616 vss_1v2.n1653 vss_1v2.n1610 0.0626176
R7617 vss_1v2.n1653 vss_1v2.n1607 0.0626176
R7618 vss_1v2.n1659 vss_1v2.n1607 0.0626176
R7619 vss_1v2.n1659 vss_1v2.n1605 0.0626176
R7620 vss_1v2.n1663 vss_1v2.n1605 0.0626176
R7621 vss_1v2.n1663 vss_1v2.n1601 0.0626176
R7622 vss_1v2.n1668 vss_1v2.n1601 0.0626176
R7623 vss_1v2.n1668 vss_1v2.n1599 0.0626176
R7624 vss_1v2.n1672 vss_1v2.n1599 0.0626176
R7625 vss_1v2.n1672 vss_1v2.n1595 0.0626176
R7626 vss_1v2.n1677 vss_1v2.n1595 0.0626176
R7627 vss_1v2.n1677 vss_1v2.n1593 0.0626176
R7628 vss_1v2.n1681 vss_1v2.n1593 0.0626176
R7629 vss_1v2.n1681 vss_1v2.n1589 0.0626176
R7630 vss_1v2.n1687 vss_1v2.n1589 0.0626176
R7631 vss_1v2.n1687 vss_1v2.n1587 0.0626176
R7632 vss_1v2.n1691 vss_1v2.n1587 0.0626176
R7633 vss_1v2.n1691 vss_1v2.n1583 0.0626176
R7634 vss_1v2.n1696 vss_1v2.n1583 0.0626176
R7635 vss_1v2.n1696 vss_1v2.n1581 0.0626176
R7636 vss_1v2.n1700 vss_1v2.n1581 0.0626176
R7637 vss_1v2.n1700 vss_1v2.n1577 0.0626176
R7638 vss_1v2.n1705 vss_1v2.n1577 0.0626176
R7639 vss_1v2.n1705 vss_1v2.n1575 0.0626176
R7640 vss_1v2.n1709 vss_1v2.n1575 0.0626176
R7641 vss_1v2.n1709 vss_1v2.n1571 0.0626176
R7642 vss_1v2.n1714 vss_1v2.n1571 0.0626176
R7643 vss_1v2.n1714 vss_1v2.n1569 0.0626176
R7644 vss_1v2.n1718 vss_1v2.n1569 0.0626176
R7645 vss_1v2.n1718 vss_1v2.n1565 0.0626176
R7646 vss_1v2.n1723 vss_1v2.n1565 0.0626176
R7647 vss_1v2.n1723 vss_1v2.n1563 0.0626176
R7648 vss_1v2.n1727 vss_1v2.n1563 0.0626176
R7649 vss_1v2.n1727 vss_1v2.n1559 0.0626176
R7650 vss_1v2.n1732 vss_1v2.n1559 0.0626176
R7651 vss_1v2.n1732 vss_1v2.n1557 0.0626176
R7652 vss_1v2.n1736 vss_1v2.n1557 0.0626176
R7653 vss_1v2.n1736 vss_1v2.n1553 0.0626176
R7654 vss_1v2.n1742 vss_1v2.n1553 0.0626176
R7655 vss_1v2.n1742 vss_1v2.n1551 0.0626176
R7656 vss_1v2.n1746 vss_1v2.n1551 0.0626176
R7657 vss_1v2.n1746 vss_1v2.n1547 0.0626176
R7658 vss_1v2.n1752 vss_1v2.n1547 0.0626176
R7659 vss_1v2.n1752 vss_1v2.n1545 0.0626176
R7660 vss_1v2.n1756 vss_1v2.n1545 0.0626176
R7661 vss_1v2.n1756 vss_1v2.n1542 0.0626176
R7662 vss_1v2.n1761 vss_1v2.n1542 0.0626176
R7663 vss_1v2.n1761 vss_1v2.n1540 0.0626176
R7664 vss_1v2.n1765 vss_1v2.n1540 0.0626176
R7665 vss_1v2.n1765 vss_1v2.n1536 0.0626176
R7666 vss_1v2.n1771 vss_1v2.n1536 0.0626176
R7667 vss_1v2.n1771 vss_1v2.n1534 0.0626176
R7668 vss_1v2.n1775 vss_1v2.n1534 0.0626176
R7669 vss_1v2.n1775 vss_1v2.n1531 0.0626176
R7670 vss_1v2.n1781 vss_1v2.n1531 0.0626176
R7671 vss_1v2.n1781 vss_1v2.n1529 0.0626176
R7672 vss_1v2.n1785 vss_1v2.n1529 0.0626176
R7673 vss_1v2.n1785 vss_1v2.n1525 0.0626176
R7674 vss_1v2.n1791 vss_1v2.n1525 0.0626176
R7675 vss_1v2.n1791 vss_1v2.n1523 0.0626176
R7676 vss_1v2.n1795 vss_1v2.n1523 0.0626176
R7677 vss_1v2.n1795 vss_1v2.n1520 0.0626176
R7678 vss_1v2.n1801 vss_1v2.n1520 0.0626176
R7679 vss_1v2.n1801 vss_1v2.n1518 0.0626176
R7680 vss_1v2.n1805 vss_1v2.n1518 0.0626176
R7681 vss_1v2.n1805 vss_1v2.n1515 0.0626176
R7682 vss_1v2.n1811 vss_1v2.n1515 0.0626176
R7683 vss_1v2.n1811 vss_1v2.n1513 0.0626176
R7684 vss_1v2.n1815 vss_1v2.n1513 0.0626176
R7685 vss_1v2.n1815 vss_1v2.n1510 0.0626176
R7686 vss_1v2.n1821 vss_1v2.n1510 0.0626176
R7687 vss_1v2.n1821 vss_1v2.n1508 0.0626176
R7688 vss_1v2.n1825 vss_1v2.n1508 0.0626176
R7689 vss_1v2.n1825 vss_1v2.n1504 0.0626176
R7690 vss_1v2.n1831 vss_1v2.n1504 0.0626176
R7691 vss_1v2.n1831 vss_1v2.n1458 0.0626176
R7692 vss_1v2.n1835 vss_1v2.n1458 0.0626176
R7693 vss_1v2.n1835 vss_1v2.n1457 0.0626176
R7694 vss_1v2.n1500 vss_1v2.n1457 0.0626176
R7695 vss_1v2.n1500 vss_1v2.n1460 0.0626176
R7696 vss_1v2.n1495 vss_1v2.n1460 0.0626176
R7697 vss_1v2.n1495 vss_1v2.n1464 0.0626176
R7698 vss_1v2.n1491 vss_1v2.n1464 0.0626176
R7699 vss_1v2.n1491 vss_1v2.n1466 0.0626176
R7700 vss_1v2.n1485 vss_1v2.n1466 0.0626176
R7701 vss_1v2.n1485 vss_1v2.n1470 0.0626176
R7702 vss_1v2.n1481 vss_1v2.n1470 0.0626176
R7703 vss_1v2.n1481 vss_1v2.n1472 0.0626176
R7704 vss_1v2.n1475 vss_1v2.n1472 0.0626176
R7705 vss_1v2.n1475 vss_1v2.n491 0.0626176
R7706 vss_1v2.n4151 vss_1v2.n491 0.0626176
R7707 vss_1v2.n4151 vss_1v2.n490 0.0626176
R7708 vss_1v2.n1120 vss_1v2.n490 0.0626176
R7709 vss_1v2.n1120 vss_1v2.n1117 0.0626176
R7710 vss_1v2.n1124 vss_1v2.n1117 0.0626176
R7711 vss_1v2.n1124 vss_1v2.n1114 0.0626176
R7712 vss_1v2.n1130 vss_1v2.n1114 0.0626176
R7713 vss_1v2.n1130 vss_1v2.n1112 0.0626176
R7714 vss_1v2.n1134 vss_1v2.n1112 0.0626176
R7715 vss_1v2.n1134 vss_1v2.n1108 0.0626176
R7716 vss_1v2.n1140 vss_1v2.n1108 0.0626176
R7717 vss_1v2.n1140 vss_1v2.n1106 0.0626176
R7718 vss_1v2.n1144 vss_1v2.n1106 0.0626176
R7719 vss_1v2.n1144 vss_1v2.n1102 0.0626176
R7720 vss_1v2.n1150 vss_1v2.n1102 0.0626176
R7721 vss_1v2.n1150 vss_1v2.n1100 0.0626176
R7722 vss_1v2.n1154 vss_1v2.n1100 0.0626176
R7723 vss_1v2.n1154 vss_1v2.n1096 0.0626176
R7724 vss_1v2.n1159 vss_1v2.n1096 0.0626176
R7725 vss_1v2.n1159 vss_1v2.n1094 0.0626176
R7726 vss_1v2.n1163 vss_1v2.n1094 0.0626176
R7727 vss_1v2.n1163 vss_1v2.n1091 0.0626176
R7728 vss_1v2.n1169 vss_1v2.n1091 0.0626176
R7729 vss_1v2.n1169 vss_1v2.n1089 0.0626176
R7730 vss_1v2.n1173 vss_1v2.n1089 0.0626176
R7731 vss_1v2.n1173 vss_1v2.n1085 0.0626176
R7732 vss_1v2.n1178 vss_1v2.n1085 0.0626176
R7733 vss_1v2.n1178 vss_1v2.n1083 0.0626176
R7734 vss_1v2.n1182 vss_1v2.n1083 0.0626176
R7735 vss_1v2.n1182 vss_1v2.n1079 0.0626176
R7736 vss_1v2.n1188 vss_1v2.n1079 0.0626176
R7737 vss_1v2.n1188 vss_1v2.n1077 0.0626176
R7738 vss_1v2.n1192 vss_1v2.n1077 0.0626176
R7739 vss_1v2.n1192 vss_1v2.n1073 0.0626176
R7740 vss_1v2.n1198 vss_1v2.n1073 0.0626176
R7741 vss_1v2.n1198 vss_1v2.n1071 0.0626176
R7742 vss_1v2.n1202 vss_1v2.n1071 0.0626176
R7743 vss_1v2.n1202 vss_1v2.n1067 0.0626176
R7744 vss_1v2.n1207 vss_1v2.n1067 0.0626176
R7745 vss_1v2.n1207 vss_1v2.n1064 0.0626176
R7746 vss_1v2.n1211 vss_1v2.n1064 0.0626176
R7747 vss_1v2.n1211 vss_1v2.n1063 0.0626176
R7748 vss_1v2.n1063 vss_1v2.n947 0.0626176
R7749 vss_1v2.n4139 vss_1v2.n947 0.0626176
R7750 vss_1v2.n4139 vss_1v2.n944 0.0626176
R7751 vss_1v2.n4143 vss_1v2.n944 0.0626176
R7752 vss_1v2.n4143 vss_1v2.n943 0.0626176
R7753 vss_1v2.n3606 vss_1v2.n943 0.0626176
R7754 vss_1v2.n3610 vss_1v2.n3606 0.0626176
R7755 vss_1v2.n3612 vss_1v2.n3610 0.0626176
R7756 vss_1v2.n3614 vss_1v2.n3612 0.0626176
R7757 vss_1v2.n3614 vss_1v2.n3603 0.0626176
R7758 vss_1v2.n3618 vss_1v2.n3603 0.0626176
R7759 vss_1v2.n3620 vss_1v2.n3618 0.0626176
R7760 vss_1v2.n3622 vss_1v2.n3620 0.0626176
R7761 vss_1v2.n3622 vss_1v2.n3599 0.0626176
R7762 vss_1v2.n3626 vss_1v2.n3599 0.0626176
R7763 vss_1v2.n3626 vss_1v2.n3597 0.0626176
R7764 vss_1v2.n3597 vss_1v2.n2656 0.0626176
R7765 vss_1v2.n3632 vss_1v2.n2656 0.0626176
R7766 vss_1v2.n3632 vss_1v2.n2654 0.0626176
R7767 vss_1v2.n3636 vss_1v2.n2654 0.0626176
R7768 vss_1v2.n3636 vss_1v2.n2636 0.0626176
R7769 vss_1v2.n3645 vss_1v2.n2636 0.0626176
R7770 vss_1v2.n3645 vss_1v2.n2634 0.0626176
R7771 vss_1v2.n3649 vss_1v2.n2634 0.0626176
R7772 vss_1v2.n3649 vss_1v2.n2626 0.0626176
R7773 vss_1v2.n3661 vss_1v2.n2626 0.0626176
R7774 vss_1v2.n3661 vss_1v2.n2624 0.0626176
R7775 vss_1v2.n3665 vss_1v2.n2624 0.0626176
R7776 vss_1v2.n3665 vss_1v2.n2616 0.0626176
R7777 vss_1v2.n3673 vss_1v2.n2616 0.0626176
R7778 vss_1v2.n3673 vss_1v2.n2614 0.0626176
R7779 vss_1v2.n3677 vss_1v2.n2614 0.0626176
R7780 vss_1v2.n3677 vss_1v2.n2605 0.0626176
R7781 vss_1v2.n3683 vss_1v2.n2605 0.0626176
R7782 vss_1v2.n3683 vss_1v2.n2603 0.0626176
R7783 vss_1v2.n3687 vss_1v2.n2603 0.0626176
R7784 vss_1v2.n3687 vss_1v2.n2594 0.0626176
R7785 vss_1v2.n3699 vss_1v2.n2594 0.0626176
R7786 vss_1v2.n3699 vss_1v2.n2592 0.0626176
R7787 vss_1v2.n3703 vss_1v2.n2592 0.0626176
R7788 vss_1v2.n3703 vss_1v2.n2582 0.0626176
R7789 vss_1v2.n3714 vss_1v2.n2582 0.0626176
R7790 vss_1v2.n3714 vss_1v2.n2580 0.0626176
R7791 vss_1v2.n3718 vss_1v2.n2580 0.0626176
R7792 vss_1v2.n3718 vss_1v2.n2573 0.0626176
R7793 vss_1v2.n3724 vss_1v2.n2573 0.0626176
R7794 vss_1v2.n3724 vss_1v2.n2571 0.0626176
R7795 vss_1v2.n3728 vss_1v2.n2571 0.0626176
R7796 vss_1v2.n3728 vss_1v2.n2563 0.0626176
R7797 vss_1v2.n3740 vss_1v2.n2563 0.0626176
R7798 vss_1v2.n3740 vss_1v2.n2561 0.0626176
R7799 vss_1v2.n3744 vss_1v2.n2561 0.0626176
R7800 vss_1v2.n3744 vss_1v2.n2552 0.0626176
R7801 vss_1v2.n3752 vss_1v2.n2552 0.0626176
R7802 vss_1v2.n3752 vss_1v2.n2550 0.0626176
R7803 vss_1v2.n3756 vss_1v2.n2550 0.0626176
R7804 vss_1v2.n3756 vss_1v2.n2541 0.0626176
R7805 vss_1v2.n3762 vss_1v2.n2541 0.0626176
R7806 vss_1v2.n3762 vss_1v2.n2539 0.0626176
R7807 vss_1v2.n3766 vss_1v2.n2539 0.0626176
R7808 vss_1v2.n3766 vss_1v2.n2531 0.0626176
R7809 vss_1v2.n3778 vss_1v2.n2531 0.0626176
R7810 vss_1v2.n3778 vss_1v2.n2529 0.0626176
R7811 vss_1v2.n1626 vss_1v2.n1624 0.0626176
R7812 vss_1v2.n1628 vss_1v2.n1626 0.0626176
R7813 vss_1v2.n1628 vss_1v2.n1620 0.0626176
R7814 vss_1v2.n1634 vss_1v2.n1620 0.0626176
R7815 vss_1v2.n1636 vss_1v2.n1634 0.0626176
R7816 vss_1v2.n1638 vss_1v2.n1636 0.0626176
R7817 vss_1v2.n1638 vss_1v2.n1614 0.0626176
R7818 vss_1v2.n1644 vss_1v2.n1614 0.0626176
R7819 vss_1v2.n1646 vss_1v2.n1644 0.0626176
R7820 vss_1v2.n1648 vss_1v2.n1646 0.0626176
R7821 vss_1v2.n1648 vss_1v2.n1609 0.0626176
R7822 vss_1v2.n1654 vss_1v2.n1609 0.0626176
R7823 vss_1v2.n1656 vss_1v2.n1654 0.0626176
R7824 vss_1v2.n1658 vss_1v2.n1656 0.0626176
R7825 vss_1v2.n1658 vss_1v2.n1603 0.0626176
R7826 vss_1v2.n1664 vss_1v2.n1603 0.0626176
R7827 vss_1v2.n1665 vss_1v2.n1664 0.0626176
R7828 vss_1v2.n1667 vss_1v2.n1665 0.0626176
R7829 vss_1v2.n1667 vss_1v2.n1597 0.0626176
R7830 vss_1v2.n1673 vss_1v2.n1597 0.0626176
R7831 vss_1v2.n1674 vss_1v2.n1673 0.0626176
R7832 vss_1v2.n1676 vss_1v2.n1674 0.0626176
R7833 vss_1v2.n1676 vss_1v2.n1591 0.0626176
R7834 vss_1v2.n1682 vss_1v2.n1591 0.0626176
R7835 vss_1v2.n1684 vss_1v2.n1682 0.0626176
R7836 vss_1v2.n1686 vss_1v2.n1684 0.0626176
R7837 vss_1v2.n1686 vss_1v2.n1585 0.0626176
R7838 vss_1v2.n1692 vss_1v2.n1585 0.0626176
R7839 vss_1v2.n1693 vss_1v2.n1692 0.0626176
R7840 vss_1v2.n1695 vss_1v2.n1693 0.0626176
R7841 vss_1v2.n1695 vss_1v2.n1579 0.0626176
R7842 vss_1v2.n1701 vss_1v2.n1579 0.0626176
R7843 vss_1v2.n1703 vss_1v2.n1701 0.0626176
R7844 vss_1v2.n1704 vss_1v2.n1703 0.0626176
R7845 vss_1v2.n1704 vss_1v2.n1573 0.0626176
R7846 vss_1v2.n1710 vss_1v2.n1573 0.0626176
R7847 vss_1v2.n1712 vss_1v2.n1710 0.0626176
R7848 vss_1v2.n1713 vss_1v2.n1712 0.0626176
R7849 vss_1v2.n1713 vss_1v2.n1567 0.0626176
R7850 vss_1v2.n1719 vss_1v2.n1567 0.0626176
R7851 vss_1v2.n1720 vss_1v2.n1719 0.0626176
R7852 vss_1v2.n1722 vss_1v2.n1720 0.0626176
R7853 vss_1v2.n1722 vss_1v2.n1561 0.0626176
R7854 vss_1v2.n1728 vss_1v2.n1561 0.0626176
R7855 vss_1v2.n1730 vss_1v2.n1728 0.0626176
R7856 vss_1v2.n1731 vss_1v2.n1730 0.0626176
R7857 vss_1v2.n1731 vss_1v2.n1555 0.0626176
R7858 vss_1v2.n1737 vss_1v2.n1555 0.0626176
R7859 vss_1v2.n1739 vss_1v2.n1737 0.0626176
R7860 vss_1v2.n1741 vss_1v2.n1739 0.0626176
R7861 vss_1v2.n1741 vss_1v2.n1549 0.0626176
R7862 vss_1v2.n1747 vss_1v2.n1549 0.0626176
R7863 vss_1v2.n1749 vss_1v2.n1747 0.0626176
R7864 vss_1v2.n1751 vss_1v2.n1749 0.0626176
R7865 vss_1v2.n1751 vss_1v2.n1543 0.0626176
R7866 vss_1v2.n1757 vss_1v2.n1543 0.0626176
R7867 vss_1v2.n1759 vss_1v2.n1757 0.0626176
R7868 vss_1v2.n1760 vss_1v2.n1759 0.0626176
R7869 vss_1v2.n1760 vss_1v2.n1538 0.0626176
R7870 vss_1v2.n1766 vss_1v2.n1538 0.0626176
R7871 vss_1v2.n1768 vss_1v2.n1766 0.0626176
R7872 vss_1v2.n1770 vss_1v2.n1768 0.0626176
R7873 vss_1v2.n1770 vss_1v2.n1532 0.0626176
R7874 vss_1v2.n1776 vss_1v2.n1532 0.0626176
R7875 vss_1v2.n1778 vss_1v2.n1776 0.0626176
R7876 vss_1v2.n1780 vss_1v2.n1778 0.0626176
R7877 vss_1v2.n1780 vss_1v2.n1527 0.0626176
R7878 vss_1v2.n1786 vss_1v2.n1527 0.0626176
R7879 vss_1v2.n1788 vss_1v2.n1786 0.0626176
R7880 vss_1v2.n1790 vss_1v2.n1788 0.0626176
R7881 vss_1v2.n1790 vss_1v2.n1522 0.0626176
R7882 vss_1v2.n1796 vss_1v2.n1522 0.0626176
R7883 vss_1v2.n1798 vss_1v2.n1796 0.0626176
R7884 vss_1v2.n1800 vss_1v2.n1798 0.0626176
R7885 vss_1v2.n1800 vss_1v2.n1516 0.0626176
R7886 vss_1v2.n1806 vss_1v2.n1516 0.0626176
R7887 vss_1v2.n1808 vss_1v2.n1806 0.0626176
R7888 vss_1v2.n1810 vss_1v2.n1808 0.0626176
R7889 vss_1v2.n1810 vss_1v2.n1512 0.0626176
R7890 vss_1v2.n1816 vss_1v2.n1512 0.0626176
R7891 vss_1v2.n1818 vss_1v2.n1816 0.0626176
R7892 vss_1v2.n1820 vss_1v2.n1818 0.0626176
R7893 vss_1v2.n1820 vss_1v2.n1506 0.0626176
R7894 vss_1v2.n1826 vss_1v2.n1506 0.0626176
R7895 vss_1v2.n1828 vss_1v2.n1826 0.0626176
R7896 vss_1v2.n1830 vss_1v2.n1828 0.0626176
R7897 vss_1v2.n1830 vss_1v2.n1456 0.0626176
R7898 vss_1v2.n1836 vss_1v2.n1456 0.0626176
R7899 vss_1v2.n1836 vss_1v2.n1454 0.0626176
R7900 vss_1v2.n1499 vss_1v2.n1454 0.0626176
R7901 vss_1v2.n1499 vss_1v2.n1497 0.0626176
R7902 vss_1v2.n1497 vss_1v2.n1496 0.0626176
R7903 vss_1v2.n1496 vss_1v2.n1462 0.0626176
R7904 vss_1v2.n1490 vss_1v2.n1462 0.0626176
R7905 vss_1v2.n1490 vss_1v2.n1488 0.0626176
R7906 vss_1v2.n1488 vss_1v2.n1486 0.0626176
R7907 vss_1v2.n1486 vss_1v2.n1468 0.0626176
R7908 vss_1v2.n1480 vss_1v2.n1468 0.0626176
R7909 vss_1v2.n1480 vss_1v2.n1478 0.0626176
R7910 vss_1v2.n1478 vss_1v2.n1476 0.0626176
R7911 vss_1v2.n1476 vss_1v2.n493 0.0626176
R7912 vss_1v2.n4150 vss_1v2.n493 0.0626176
R7913 vss_1v2.n4150 vss_1v2.n492 0.0626176
R7914 vss_1v2.n1119 vss_1v2.n492 0.0626176
R7915 vss_1v2.n1119 vss_1v2.n1115 0.0626176
R7916 vss_1v2.n1125 vss_1v2.n1115 0.0626176
R7917 vss_1v2.n1127 vss_1v2.n1125 0.0626176
R7918 vss_1v2.n1129 vss_1v2.n1127 0.0626176
R7919 vss_1v2.n1129 vss_1v2.n1110 0.0626176
R7920 vss_1v2.n1135 vss_1v2.n1110 0.0626176
R7921 vss_1v2.n1137 vss_1v2.n1135 0.0626176
R7922 vss_1v2.n1139 vss_1v2.n1137 0.0626176
R7923 vss_1v2.n1139 vss_1v2.n1104 0.0626176
R7924 vss_1v2.n1145 vss_1v2.n1104 0.0626176
R7925 vss_1v2.n1147 vss_1v2.n1145 0.0626176
R7926 vss_1v2.n1149 vss_1v2.n1147 0.0626176
R7927 vss_1v2.n1149 vss_1v2.n1098 0.0626176
R7928 vss_1v2.n1155 vss_1v2.n1098 0.0626176
R7929 vss_1v2.n1157 vss_1v2.n1155 0.0626176
R7930 vss_1v2.n1158 vss_1v2.n1157 0.0626176
R7931 vss_1v2.n1158 vss_1v2.n1093 0.0626176
R7932 vss_1v2.n1164 vss_1v2.n1093 0.0626176
R7933 vss_1v2.n1166 vss_1v2.n1164 0.0626176
R7934 vss_1v2.n1168 vss_1v2.n1166 0.0626176
R7935 vss_1v2.n1168 vss_1v2.n1087 0.0626176
R7936 vss_1v2.n1174 vss_1v2.n1087 0.0626176
R7937 vss_1v2.n1175 vss_1v2.n1174 0.0626176
R7938 vss_1v2.n1177 vss_1v2.n1175 0.0626176
R7939 vss_1v2.n1177 vss_1v2.n1081 0.0626176
R7940 vss_1v2.n1183 vss_1v2.n1081 0.0626176
R7941 vss_1v2.n1185 vss_1v2.n1183 0.0626176
R7942 vss_1v2.n1187 vss_1v2.n1185 0.0626176
R7943 vss_1v2.n1187 vss_1v2.n1075 0.0626176
R7944 vss_1v2.n1193 vss_1v2.n1075 0.0626176
R7945 vss_1v2.n1195 vss_1v2.n1193 0.0626176
R7946 vss_1v2.n1197 vss_1v2.n1195 0.0626176
R7947 vss_1v2.n1197 vss_1v2.n1069 0.0626176
R7948 vss_1v2.n1203 vss_1v2.n1069 0.0626176
R7949 vss_1v2.n1204 vss_1v2.n1203 0.0626176
R7950 vss_1v2.n1206 vss_1v2.n1204 0.0626176
R7951 vss_1v2.n1206 vss_1v2.n1062 0.0626176
R7952 vss_1v2.n1212 vss_1v2.n1062 0.0626176
R7953 vss_1v2.n1212 vss_1v2.n1060 0.0626176
R7954 vss_1v2.n1060 vss_1v2.n948 0.0626176
R7955 vss_1v2.n4138 vss_1v2.n948 0.0626176
R7956 vss_1v2.n4138 vss_1v2.n942 0.0626176
R7957 vss_1v2.n4144 vss_1v2.n942 0.0626176
R7958 vss_1v2.n4144 vss_1v2.n941 0.0626176
R7959 vss_1v2.n3591 vss_1v2.n941 0.0626176
R7960 vss_1v2.n3644 vss_1v2.n2637 0.0626176
R7961 vss_1v2.n3644 vss_1v2.n2633 0.0626176
R7962 vss_1v2.n3650 vss_1v2.n2633 0.0626176
R7963 vss_1v2.n3650 vss_1v2.n2627 0.0626176
R7964 vss_1v2.n3660 vss_1v2.n2627 0.0626176
R7965 vss_1v2.n3660 vss_1v2.n2623 0.0626176
R7966 vss_1v2.n3666 vss_1v2.n2623 0.0626176
R7967 vss_1v2.n3666 vss_1v2.n2617 0.0626176
R7968 vss_1v2.n3672 vss_1v2.n2617 0.0626176
R7969 vss_1v2.n3672 vss_1v2.n2613 0.0626176
R7970 vss_1v2.n3678 vss_1v2.n2613 0.0626176
R7971 vss_1v2.n3678 vss_1v2.n456 0.0626176
R7972 vss_1v2.n3682 vss_1v2.n456 0.0626176
R7973 vss_1v2.n3682 vss_1v2.n2602 0.0626176
R7974 vss_1v2.n3688 vss_1v2.n2602 0.0626176
R7975 vss_1v2.n3688 vss_1v2.n2595 0.0626176
R7976 vss_1v2.n3698 vss_1v2.n2595 0.0626176
R7977 vss_1v2.n3698 vss_1v2.n2591 0.0626176
R7978 vss_1v2.n3704 vss_1v2.n2591 0.0626176
R7979 vss_1v2.n3704 vss_1v2.n2583 0.0626176
R7980 vss_1v2.n3713 vss_1v2.n2583 0.0626176
R7981 vss_1v2.n3713 vss_1v2.n2579 0.0626176
R7982 vss_1v2.n3719 vss_1v2.n2579 0.0626176
R7983 vss_1v2.n3719 vss_1v2.n479 0.0626176
R7984 vss_1v2.n3723 vss_1v2.n479 0.0626176
R7985 vss_1v2.n3723 vss_1v2.n2570 0.0626176
R7986 vss_1v2.n3729 vss_1v2.n2570 0.0626176
R7987 vss_1v2.n3729 vss_1v2.n2564 0.0626176
R7988 vss_1v2.n3739 vss_1v2.n2564 0.0626176
R7989 vss_1v2.n3739 vss_1v2.n2560 0.0626176
R7990 vss_1v2.n3745 vss_1v2.n2560 0.0626176
R7991 vss_1v2.n3745 vss_1v2.n2553 0.0626176
R7992 vss_1v2.n3751 vss_1v2.n2553 0.0626176
R7993 vss_1v2.n3751 vss_1v2.n2549 0.0626176
R7994 vss_1v2.n3757 vss_1v2.n2549 0.0626176
R7995 vss_1v2.n3757 vss_1v2.n458 0.0626176
R7996 vss_1v2.n3761 vss_1v2.n458 0.0626176
R7997 vss_1v2.n3761 vss_1v2.n2538 0.0626176
R7998 vss_1v2.n3767 vss_1v2.n2538 0.0626176
R7999 vss_1v2.n3767 vss_1v2.n2532 0.0626176
R8000 vss_1v2.n3777 vss_1v2.n2532 0.0626176
R8001 vss_1v2.n3777 vss_1v2.n2528 0.0626176
R8002 vss_1v2.n3781 vss_1v2.n2528 0.0626176
R8003 vss_1v2.n4133 vss_1v2.n1268 0.059451
R8004 vss_1v2.n4103 vss_1v2.n38 0.0735813
R8005 vss_1v2.n1953 vss_1v2.n26 0.146605
R8006 vss_1v2.n79 vss_1v2.n4061 0.0735813
R8007 vss_1v2.n2 vss_1v2.t105 0.242816
R8008 vss_1v2.n12 vss_1v2.n574 0.0577365
R8009 vss_1v2.n353 vss_1v2.n351 0.0573966
R8010 vss_1v2.n408 vss_1v2.n406 0.0555
R8011 vss_1v2.n4133 vss_1v2.n1221 0.0554721
R8012 vss_1v2.n78 vss_1v2.n4106 0.0846183
R8013 vss_1v2.n4102 vss_1v2.n48 0.146297
R8014 vss_1v2.n30 vss_1v2.n36 0.264074
R8015 vss_1v2.n4062 vss_1v2.n52 0.119014
R8016 vss_1v2.n52 vss_1v2.n21 0.111157
R8017 vss_1v2.n3555 vss_1v2.n3554 0.0539286
R8018 vss_1v2.n3233 vss_1v2.n3232 0.0539286
R8019 vss_1v2.n2662 vss_1v2.n2660 0.0538333
R8020 vss_1v2.n2841 vss_1v2.n1976 0.0507857
R8021 vss_1v2.n3561 vss_1v2.n2815 0.0507857
R8022 vss_1v2.n2689 vss_1v2.n2683 0.0507857
R8023 vss_1v2.n3088 vss_1v2.n2882 0.0507857
R8024 vss_1v2.n3224 vss_1v2.n3216 0.0507857
R8025 vss_1v2.n3164 vss_1v2.n2984 0.0507857
R8026 vss_1v2.n3145 vss_1v2.n3142 0.0507857
R8027 vss_1v2.n3240 vss_1v2.n3238 0.0507857
R8028 vss_1v2.n2897 vss_1v2.n2894 0.0507857
R8029 vss_1v2.n3316 vss_1v2.n2658 0.0497105
R8030 vss_1v2.n4111 vss_1v2.n30 0.248908
R8031 vss_1v2.n3589 vss_1v2.n939 0.0489868
R8032 vss_1v2.n3581 vss_1v2.n2682 0.0480592
R8033 vss_1v2.n3129 vss_1v2.n2986 0.0480592
R8034 vss_1v2.n3089 vss_1v2.n2886 0.0480592
R8035 vss_1v2.n4129 vss_1v2.n1877 0.0451935
R8036 vss_1v2.t12 vss_1v2.n3313 0.0449444
R8037 vss_1v2.n4024 vss_1v2.n1981 0.0449163
R8038 vss_1v2.t56 vss_1v2.n3843 0.0445
R8039 vss_1v2.t56 vss_1v2.n2442 0.0445
R8040 vss_1v2.n3064 vss_1v2.n1295 0.0425142
R8041 vss_1v2.n3891 vss_1v2.n3889 0.0423
R8042 vss_1v2.n4133 vss_1v2.n1228 0.0399072
R8043 vss_1v2.n3063 vss_1v2.n3062 0.0397857
R8044 vss_1v2.n1302 vss_1v2.n1298 0.0396737
R8045 vss_1v2.n4103 vss_1v2.n207 0.0382143
R8046 vss_1v2.n4112 vss_1v2.n1957 0.0382143
R8047 vss_1v2.n23 vss_1v2.n1840 0.118882
R8048 vss_1v2.n27 vss_1v2.t46 0.516473
R8049 vss_1v2.n4061 vss_1v2.n37 0.225131
R8050 vss_1v2.n3846 vss_1v2.n3845 0.0379
R8051 vss_1v2.n3847 vss_1v2.n3846 0.0379
R8052 vss_1v2.n3849 vss_1v2.n3847 0.0379
R8053 vss_1v2.n3850 vss_1v2.n3849 0.0379
R8054 vss_1v2.n3851 vss_1v2.n3850 0.0379
R8055 vss_1v2.n3852 vss_1v2.n3851 0.0379
R8056 vss_1v2.n3853 vss_1v2.n3852 0.0379
R8057 vss_1v2.n3854 vss_1v2.n3853 0.0379
R8058 vss_1v2.n3855 vss_1v2.n3854 0.0379
R8059 vss_1v2.n3857 vss_1v2.n3855 0.0379
R8060 vss_1v2.n3858 vss_1v2.n3857 0.0379
R8061 vss_1v2.n3859 vss_1v2.n3858 0.0379
R8062 vss_1v2.n3860 vss_1v2.n3859 0.0379
R8063 vss_1v2.n3861 vss_1v2.n3860 0.0379
R8064 vss_1v2.n3862 vss_1v2.n3861 0.0379
R8065 vss_1v2.n3863 vss_1v2.n3862 0.0379
R8066 vss_1v2.n3864 vss_1v2.n3863 0.0379
R8067 vss_1v2.n3865 vss_1v2.n3864 0.0379
R8068 vss_1v2.n3866 vss_1v2.n3865 0.0379
R8069 vss_1v2.n3867 vss_1v2.n3866 0.0379
R8070 vss_1v2.n3868 vss_1v2.n3867 0.0379
R8071 vss_1v2.n3869 vss_1v2.n3868 0.0379
R8072 vss_1v2.n3870 vss_1v2.n3869 0.0379
R8073 vss_1v2.n3871 vss_1v2.n3870 0.0379
R8074 vss_1v2.n3872 vss_1v2.n3871 0.0379
R8075 vss_1v2.n3873 vss_1v2.n3872 0.0379
R8076 vss_1v2.n3874 vss_1v2.n3873 0.0379
R8077 vss_1v2.n3875 vss_1v2.n3874 0.0379
R8078 vss_1v2.n3876 vss_1v2.n3875 0.0379
R8079 vss_1v2.n3877 vss_1v2.n3876 0.0379
R8080 vss_1v2.n3878 vss_1v2.n3877 0.0379
R8081 vss_1v2.n3879 vss_1v2.n3878 0.0379
R8082 vss_1v2.n3880 vss_1v2.n3879 0.0379
R8083 vss_1v2.n3881 vss_1v2.n3880 0.0379
R8084 vss_1v2.n3882 vss_1v2.n3881 0.0379
R8085 vss_1v2.n3883 vss_1v2.n3882 0.0379
R8086 vss_1v2.n3885 vss_1v2.n3883 0.0379
R8087 vss_1v2.n3886 vss_1v2.n3885 0.0379
R8088 vss_1v2.n3887 vss_1v2.n3886 0.0379
R8089 vss_1v2.n3888 vss_1v2.n3887 0.0379
R8090 vss_1v2.n3889 vss_1v2.n3888 0.0379
R8091 vss_1v2.n3892 vss_1v2.n3891 0.0379
R8092 vss_1v2.n3893 vss_1v2.n3892 0.0379
R8093 vss_1v2.n3895 vss_1v2.n3893 0.0379
R8094 vss_1v2.n3896 vss_1v2.n3895 0.0379
R8095 vss_1v2.n3897 vss_1v2.n3896 0.0379
R8096 vss_1v2.n3898 vss_1v2.n3897 0.0379
R8097 vss_1v2.n3899 vss_1v2.n3898 0.0379
R8098 vss_1v2.n3900 vss_1v2.n3899 0.0379
R8099 vss_1v2.n3901 vss_1v2.n3900 0.0379
R8100 vss_1v2.n3903 vss_1v2.n3901 0.0379
R8101 vss_1v2.n3904 vss_1v2.n3903 0.0379
R8102 vss_1v2.n3905 vss_1v2.n3904 0.0379
R8103 vss_1v2.n3907 vss_1v2.n3905 0.0379
R8104 vss_1v2.n3908 vss_1v2.n3907 0.0379
R8105 vss_1v2.n3909 vss_1v2.n3908 0.0379
R8106 vss_1v2.n3910 vss_1v2.n3909 0.0379
R8107 vss_1v2.n3911 vss_1v2.n3910 0.0379
R8108 vss_1v2.n3912 vss_1v2.n3911 0.0379
R8109 vss_1v2.n3913 vss_1v2.n3912 0.0379
R8110 vss_1v2.n3914 vss_1v2.n3913 0.0379
R8111 vss_1v2.n3915 vss_1v2.n3914 0.0379
R8112 vss_1v2.n3916 vss_1v2.n3915 0.0379
R8113 vss_1v2.n3917 vss_1v2.n3916 0.0379
R8114 vss_1v2.n3919 vss_1v2.n3917 0.0379
R8115 vss_1v2.n3920 vss_1v2.n3919 0.0379
R8116 vss_1v2.n3921 vss_1v2.n3920 0.0379
R8117 vss_1v2.n3922 vss_1v2.n3921 0.0379
R8118 vss_1v2.n3923 vss_1v2.n3922 0.0379
R8119 vss_1v2.n3924 vss_1v2.n3923 0.0379
R8120 vss_1v2.n3925 vss_1v2.n3924 0.0379
R8121 vss_1v2.n3926 vss_1v2.n3925 0.0379
R8122 vss_1v2.n3927 vss_1v2.n3926 0.0379
R8123 vss_1v2.n3929 vss_1v2.n3927 0.0379
R8124 vss_1v2.n3930 vss_1v2.n3929 0.0379
R8125 vss_1v2.n3931 vss_1v2.n3930 0.0379
R8126 vss_1v2.n3932 vss_1v2.n3931 0.0379
R8127 vss_1v2.n3933 vss_1v2.n3932 0.0379
R8128 vss_1v2.n3934 vss_1v2.n3933 0.0379
R8129 vss_1v2.n3935 vss_1v2.n3934 0.0379
R8130 vss_1v2.n3936 vss_1v2.n3935 0.0379
R8131 vss_1v2.n3937 vss_1v2.n3936 0.0379
R8132 vss_1v2.n3938 vss_1v2.n3937 0.0379
R8133 vss_1v2.n3939 vss_1v2.n3938 0.0379
R8134 vss_1v2.n3941 vss_1v2.n3939 0.0379
R8135 vss_1v2.n3942 vss_1v2.n3941 0.0379
R8136 vss_1v2.n3943 vss_1v2.n3942 0.0379
R8137 vss_1v2.n3944 vss_1v2.n3943 0.0379
R8138 vss_1v2.n3945 vss_1v2.n3944 0.0379
R8139 vss_1v2.n3946 vss_1v2.n3945 0.0379
R8140 vss_1v2.n3947 vss_1v2.n3946 0.0379
R8141 vss_1v2.n3948 vss_1v2.n3947 0.0379
R8142 vss_1v2.n3949 vss_1v2.n3948 0.0379
R8143 vss_1v2.n3951 vss_1v2.n3949 0.0379
R8144 vss_1v2.n3952 vss_1v2.n3951 0.0379
R8145 vss_1v2.n3953 vss_1v2.n3952 0.0379
R8146 vss_1v2.n3954 vss_1v2.n3953 0.0379
R8147 vss_1v2.n3955 vss_1v2.n3954 0.0379
R8148 vss_1v2.n3956 vss_1v2.n3955 0.0379
R8149 vss_1v2.n3957 vss_1v2.n3956 0.0379
R8150 vss_1v2.n3958 vss_1v2.n3957 0.0379
R8151 vss_1v2.n3959 vss_1v2.n3958 0.0379
R8152 vss_1v2.n3960 vss_1v2.n3959 0.0379
R8153 vss_1v2.n3961 vss_1v2.n3960 0.0379
R8154 vss_1v2.n3963 vss_1v2.n3961 0.0379
R8155 vss_1v2.n3964 vss_1v2.n3963 0.0379
R8156 vss_1v2.n3965 vss_1v2.n3964 0.0379
R8157 vss_1v2.n3966 vss_1v2.n3965 0.0379
R8158 vss_1v2.n3967 vss_1v2.n3966 0.0379
R8159 vss_1v2.n3968 vss_1v2.n3967 0.0379
R8160 vss_1v2.n3969 vss_1v2.n3968 0.0379
R8161 vss_1v2.n3970 vss_1v2.n3969 0.0379
R8162 vss_1v2.n3971 vss_1v2.n3970 0.0379
R8163 vss_1v2.n3972 vss_1v2.n3971 0.0379
R8164 vss_1v2.n3973 vss_1v2.n3972 0.0379
R8165 vss_1v2.n3975 vss_1v2.n3973 0.0379
R8166 vss_1v2.n3976 vss_1v2.n3975 0.0379
R8167 vss_1v2.n3977 vss_1v2.n3976 0.0379
R8168 vss_1v2.n3978 vss_1v2.n3977 0.0379
R8169 vss_1v2.n3979 vss_1v2.n3978 0.0379
R8170 vss_1v2.n3980 vss_1v2.n3979 0.0379
R8171 vss_1v2.n3981 vss_1v2.n3980 0.0379
R8172 vss_1v2.n3982 vss_1v2.n3981 0.0379
R8173 vss_1v2.n3983 vss_1v2.n3982 0.0379
R8174 vss_1v2.n3985 vss_1v2.n3983 0.0379
R8175 vss_1v2.n3986 vss_1v2.n3985 0.0379
R8176 vss_1v2.n3987 vss_1v2.n3986 0.0379
R8177 vss_1v2.n3988 vss_1v2.n3987 0.0379
R8178 vss_1v2.n3989 vss_1v2.n3988 0.0379
R8179 vss_1v2.n3990 vss_1v2.n3989 0.0379
R8180 vss_1v2.n3991 vss_1v2.n3990 0.0379
R8181 vss_1v2.n3992 vss_1v2.n3991 0.0379
R8182 vss_1v2.n3993 vss_1v2.n3992 0.0379
R8183 vss_1v2.n3994 vss_1v2.n3993 0.0379
R8184 vss_1v2.n3995 vss_1v2.n3994 0.0379
R8185 vss_1v2.n3997 vss_1v2.n3995 0.0379
R8186 vss_1v2.n3998 vss_1v2.n3997 0.0379
R8187 vss_1v2.n3998 vss_1v2.n2441 0.0379
R8188 vss_1v2.n2441 vss_1v2.n2440 0.0379
R8189 vss_1v2.n2440 vss_1v2.n2439 0.0379
R8190 vss_1v2.n2439 vss_1v2.n2438 0.0379
R8191 vss_1v2.n2438 vss_1v2.n2437 0.0379
R8192 vss_1v2.n2437 vss_1v2.n2436 0.0379
R8193 vss_1v2.n2436 vss_1v2.n2435 0.0379
R8194 vss_1v2.n2435 vss_1v2.n2434 0.0379
R8195 vss_1v2.n2434 vss_1v2.n2433 0.0379
R8196 vss_1v2.n2433 vss_1v2.n2283 0.0379
R8197 vss_1v2.n4005 vss_1v2.n2283 0.0379
R8198 vss_1v2.n4006 vss_1v2.n4005 0.0379
R8199 vss_1v2.n4007 vss_1v2.n4006 0.0379
R8200 vss_1v2.n4008 vss_1v2.n4007 0.0379
R8201 vss_1v2.n4009 vss_1v2.n4008 0.0379
R8202 vss_1v2.n4010 vss_1v2.n4009 0.0379
R8203 vss_1v2.n4011 vss_1v2.n4010 0.0379
R8204 vss_1v2.n4012 vss_1v2.n4011 0.0379
R8205 vss_1v2.n4013 vss_1v2.n4012 0.0379
R8206 vss_1v2.n4013 vss_1v2.n2282 0.0379
R8207 vss_1v2.n2282 vss_1v2.n2281 0.0379
R8208 vss_1v2.n48 vss_1v2.n4101 0.119212
R8209 vss_1v2.n2881 vss_1v2.t20 0.0374286
R8210 vss_1v2.n4028 vss_1v2.n1978 0.0374286
R8211 vss_1v2.n3564 vss_1v2.n2814 0.0374286
R8212 vss_1v2.n3068 vss_1v2.n2690 0.0374286
R8213 vss_1v2.n3344 vss_1v2.n3212 0.0374286
R8214 vss_1v2.n3163 vss_1v2.n2981 0.0374286
R8215 vss_1v2.n3148 vss_1v2.n3128 0.0374286
R8216 vss_1v2.n3331 vss_1v2.n1225 0.0374286
R8217 vss_1v2.n3491 vss_1v2.n2898 0.0374286
R8218 vss_1v2.n2815 vss_1v2.n2682 0.0370592
R8219 vss_1v2.n3142 vss_1v2.n3129 0.0370592
R8220 vss_1v2.n3089 vss_1v2.n3088 0.0370592
R8221 vss_1v2.n1998 vss_1v2.n1994 0.0356205
R8222 vss_1v2.n2446 vss_1v2.n2444 0.0356205
R8223 vss_1v2.n4084 vss_1v2.n4079 0.0356205
R8224 vss_1v2.n4091 vss_1v2.n4090 0.0356205
R8225 vss_1v2.n3241 vss_1v2.n462 0.0329634
R8226 vss_1v2.n3323 vss_1v2.n3313 0.0323421
R8227 vss_1v2.n3780 vss_1v2.n2529 0.0322126
R8228 vss_1v2.n1623 vss_1v2.n1622 0.0322126
R8229 vss_1v2.n3607 vss_1v2.n3592 0.031952
R8230 vss_1v2.n3613 vss_1v2.n3593 0.031952
R8231 vss_1v2.n3604 vss_1v2.n3594 0.031952
R8232 vss_1v2.n3621 vss_1v2.n3595 0.031952
R8233 vss_1v2.n3628 vss_1v2.n3627 0.031952
R8234 vss_1v2.n3631 vss_1v2.n3630 0.031952
R8235 vss_1v2.n3637 vss_1v2.n2652 0.031952
R8236 vss_1v2.n3638 vss_1v2.n3637 0.031952
R8237 vss_1v2.n3631 vss_1v2.n2651 0.031952
R8238 vss_1v2.n3596 vss_1v2.n2650 0.031952
R8239 vss_1v2.n3598 vss_1v2.n2649 0.031952
R8240 vss_1v2.n3619 vss_1v2.n2648 0.031952
R8241 vss_1v2.n3602 vss_1v2.n2647 0.031952
R8242 vss_1v2.n3611 vss_1v2.n2646 0.031952
R8243 vss_1v2.n3591 vss_1v2.n2645 0.031952
R8244 vss_1v2.n3607 vss_1v2.n2645 0.031952
R8245 vss_1v2.n3611 vss_1v2.n3592 0.031952
R8246 vss_1v2.n3613 vss_1v2.n2646 0.031952
R8247 vss_1v2.n3602 vss_1v2.n3593 0.031952
R8248 vss_1v2.n3604 vss_1v2.n2647 0.031952
R8249 vss_1v2.n3619 vss_1v2.n3594 0.031952
R8250 vss_1v2.n3621 vss_1v2.n2648 0.031952
R8251 vss_1v2.n3598 vss_1v2.n3595 0.031952
R8252 vss_1v2.n3627 vss_1v2.n2649 0.031952
R8253 vss_1v2.n3628 vss_1v2.n3596 0.031952
R8254 vss_1v2.n2657 vss_1v2.n2650 0.031952
R8255 vss_1v2.n3630 vss_1v2.n2657 0.031952
R8256 vss_1v2.n2653 vss_1v2.n2651 0.031952
R8257 vss_1v2.n2653 vss_1v2.n2652 0.031952
R8258 vss_1v2.n3638 vss_1v2.n2637 0.031952
R8259 vss_1v2.n3211 vss_1v2.n2979 0.0319286
R8260 vss_1v2.n3313 vss_1v2.n2660 0.0316111
R8261 vss_1v2.n3845 vss_1v2.t56 0.0313
R8262 vss_1v2.n4107 vss_1v2.n78 0.0850651
R8263 vss_1v2.n1978 vss_1v2.n1977 0.0303571
R8264 vss_1v2.n2814 vss_1v2.n1967 0.0303571
R8265 vss_1v2.n3069 vss_1v2.n3068 0.0303571
R8266 vss_1v2.n3063 vss_1v2.n2881 0.0303571
R8267 vss_1v2.n3212 vss_1v2.n3211 0.0303571
R8268 vss_1v2.n3211 vss_1v2.n2981 0.0303571
R8269 vss_1v2.n3128 vss_1v2.n3127 0.0303571
R8270 vss_1v2.n1269 vss_1v2.n1225 0.0303571
R8271 vss_1v2.n3022 vss_1v2.n2898 0.0303571
R8272 vss_1v2.n1877 vss_1v2.n717 0.0301431
R8273 vss_1v2.n3062 vss_1v2.n2880 0.0299643
R8274 vss_1v2.n1274 vss_1v2.n1273 0.028
R8275 vss_1v2.n4146 vss_1v2.n939 0.028
R8276 vss_1v2.n3324 vss_1v2.n1274 0.0272763
R8277 vss_1v2.n3316 vss_1v2.n3313 0.0272763
R8278 vss_1v2.n26 vss_1v2.n1952 0.137767
R8279 vss_1v2.n1952 vss_1v2.n24 0.138208
R8280 vss_1v2.n1303 vss_1v2.n1302 0.0272143
R8281 vss_1v2.n2445 vss_1v2.n212 0.0258795
R8282 vss_1v2.n3346 vss_1v2.n2979 0.0240714
R8283 vss_1v2.n1997 vss_1v2.n1994 0.0236928
R8284 vss_1v2.n2446 vss_1v2.n2445 0.0236928
R8285 vss_1v2.n4083 vss_1v2.n4079 0.0236928
R8286 vss_1v2.n4092 vss_1v2.n4090 0.0236928
R8287 vss_1v2.n3324 vss_1v2.n3323 0.0229342
R8288 vss_1v2.n3554 vss_1v2.n1980 0.0209286
R8289 vss_1v2.n3233 vss_1v2.n3219 0.0209286
R8290 vss_1v2.n2994 vss_1v2.n16 1.99843
R8291 vss_1v2.n3188 vss_1v2.n435 0.0187909
R8292 vss_1v2.n3188 vss_1v2.n1009 0.0187909
R8293 vss_1v2.n3311 vss_1v2.n3310 0.0187909
R8294 vss_1v2.n1270 vss_1v2.n1269 0.0176379
R8295 vss_1v2.n4028 vss_1v2.n1976 0.017
R8296 vss_1v2.n3564 vss_1v2.n3561 0.017
R8297 vss_1v2.n2690 vss_1v2.n2689 0.017
R8298 vss_1v2.t20 vss_1v2.n2882 0.017
R8299 vss_1v2.n3344 vss_1v2.n3216 0.017
R8300 vss_1v2.n3164 vss_1v2.n3163 0.017
R8301 vss_1v2.n3148 vss_1v2.n3145 0.017
R8302 vss_1v2.n3331 vss_1v2.n3240 0.017
R8303 vss_1v2.n3491 vss_1v2.n2897 0.017
R8304 vss_1v2.n3329 vss_1v2.n1270 0.0167139
R8305 vss_1v2.n38 vss_1v2.n4102 0.0716844
R8306 vss_1v2.n73 vss_1v2.n1957 0.073242
R8307 vss_1v2.n27 vss_1v2.n1840 0.130692
R8308 vss_1v2.n4062 vss_1v2.n79 0.0716844
R8309 vss_1v2.n4057 vss_1v2.n2 0.128763
R8310 vss_1v2.n4024 vss_1v2.n1980 0.0162143
R8311 vss_1v2.n37 vss_1v2.n4057 0.225937
R8312 vss_1v2.n3640 vss_1v2.n935 0.0151853
R8313 vss_1v2.n3243 vss_1v2.n3242 0.0143467
R8314 vss_1v2.n3245 vss_1v2.n3244 0.0143467
R8315 vss_1v2.n3247 vss_1v2.n3246 0.0143467
R8316 vss_1v2.n3249 vss_1v2.n3248 0.0143467
R8317 vss_1v2.n3251 vss_1v2.n3250 0.0143467
R8318 vss_1v2.n3253 vss_1v2.n3252 0.0143467
R8319 vss_1v2.n3255 vss_1v2.n3254 0.0143467
R8320 vss_1v2.n3257 vss_1v2.n3256 0.0143467
R8321 vss_1v2.n3259 vss_1v2.n3258 0.0143467
R8322 vss_1v2.n3261 vss_1v2.n3260 0.0143467
R8323 vss_1v2.n3263 vss_1v2.n3262 0.0143467
R8324 vss_1v2.n3265 vss_1v2.n3264 0.0143467
R8325 vss_1v2.n3267 vss_1v2.n3266 0.0143467
R8326 vss_1v2.n3269 vss_1v2.n3268 0.0143467
R8327 vss_1v2.n3271 vss_1v2.n3270 0.0143467
R8328 vss_1v2.n3273 vss_1v2.n3272 0.0143467
R8329 vss_1v2.n3275 vss_1v2.n3274 0.0143467
R8330 vss_1v2.n3277 vss_1v2.n3276 0.0143467
R8331 vss_1v2.n3279 vss_1v2.n3278 0.0143467
R8332 vss_1v2.n3281 vss_1v2.n3280 0.0143467
R8333 vss_1v2.n3283 vss_1v2.n3282 0.0143467
R8334 vss_1v2.n3285 vss_1v2.n3284 0.0143467
R8335 vss_1v2.n3287 vss_1v2.n3286 0.0143467
R8336 vss_1v2.n3289 vss_1v2.n3288 0.0143467
R8337 vss_1v2.n3291 vss_1v2.n3290 0.0143467
R8338 vss_1v2.n3293 vss_1v2.n3292 0.0143467
R8339 vss_1v2.n3295 vss_1v2.n3294 0.0143467
R8340 vss_1v2.n3297 vss_1v2.n3296 0.0143467
R8341 vss_1v2.n3299 vss_1v2.n3298 0.0143467
R8342 vss_1v2.n3301 vss_1v2.n3300 0.0143467
R8343 vss_1v2.n3303 vss_1v2.n3302 0.0143467
R8344 vss_1v2.n3305 vss_1v2.n3304 0.0143467
R8345 vss_1v2.n3307 vss_1v2.n3306 0.0143467
R8346 vss_1v2.n3309 vss_1v2.n3308 0.0143467
R8347 vss_1v2.n3310 vss_1v2.n3309 0.0143467
R8348 vss_1v2.n3308 vss_1v2.n3307 0.0143467
R8349 vss_1v2.n3306 vss_1v2.n3305 0.0143467
R8350 vss_1v2.n3304 vss_1v2.n3303 0.0143467
R8351 vss_1v2.n3302 vss_1v2.n3301 0.0143467
R8352 vss_1v2.n3300 vss_1v2.n3299 0.0143467
R8353 vss_1v2.n3298 vss_1v2.n3297 0.0143467
R8354 vss_1v2.n3296 vss_1v2.n3295 0.0143467
R8355 vss_1v2.n3294 vss_1v2.n3293 0.0143467
R8356 vss_1v2.n3292 vss_1v2.n3291 0.0143467
R8357 vss_1v2.n3290 vss_1v2.n3289 0.0143467
R8358 vss_1v2.n3288 vss_1v2.n3287 0.0143467
R8359 vss_1v2.n3286 vss_1v2.n3285 0.0143467
R8360 vss_1v2.n3284 vss_1v2.n3283 0.0143467
R8361 vss_1v2.n3282 vss_1v2.n3281 0.0143467
R8362 vss_1v2.n3280 vss_1v2.n3279 0.0143467
R8363 vss_1v2.n3278 vss_1v2.n3277 0.0143467
R8364 vss_1v2.n3276 vss_1v2.n3275 0.0143467
R8365 vss_1v2.n3274 vss_1v2.n3273 0.0143467
R8366 vss_1v2.n3272 vss_1v2.n3271 0.0143467
R8367 vss_1v2.n3270 vss_1v2.n3269 0.0143467
R8368 vss_1v2.n3268 vss_1v2.n3267 0.0143467
R8369 vss_1v2.n3266 vss_1v2.n3265 0.0143467
R8370 vss_1v2.n3264 vss_1v2.n3263 0.0143467
R8371 vss_1v2.n3262 vss_1v2.n3261 0.0143467
R8372 vss_1v2.n3260 vss_1v2.n3259 0.0143467
R8373 vss_1v2.n3258 vss_1v2.n3257 0.0143467
R8374 vss_1v2.n3256 vss_1v2.n3255 0.0143467
R8375 vss_1v2.n3254 vss_1v2.n3253 0.0143467
R8376 vss_1v2.n3252 vss_1v2.n3251 0.0143467
R8377 vss_1v2.n3250 vss_1v2.n3249 0.0143467
R8378 vss_1v2.n3248 vss_1v2.n3247 0.0143467
R8379 vss_1v2.n3246 vss_1v2.n3245 0.0143467
R8380 vss_1v2.n3244 vss_1v2.n3243 0.0143467
R8381 vss_1v2.n4108 vss_1v2.n4107 0.0130714
R8382 vss_1v2.n3590 vss_1v2.n3589 0.0120495
R8383 vss_1v2.n4026 vss_1v2.n4025 0.0117773
R8384 vss_1v2.n3328 vss_1v2.n3312 0.0107143
R8385 vss_1v2.n4108 vss_1v2.n207 0.0107143
R8386 vss_1v2.n4125 vss_1v2.n714 0.0106759
R8387 vss_1v2.n3331 vss_1v2.n3330 0.0106509
R8388 vss_1v2.n3640 vss_1v2.n3639 0.0106399
R8389 vss_1v2.n2841 vss_1v2.n2840 0.00992857
R8390 vss_1v2.n3580 vss_1v2.n2683 0.00992857
R8391 vss_1v2.n3133 vss_1v2.n2984 0.00992857
R8392 vss_1v2.n3238 vss_1v2.n3223 0.00992857
R8393 vss_1v2.n3232 vss_1v2.n3224 0.00992857
R8394 vss_1v2.n2889 vss_1v2.n2887 0.00992857
R8395 vss_1v2.n3312 vss_1v2.n3311 0.00989544
R8396 vss_1v2.n3629 vss_1v2.n3590 0.00986547
R8397 vss_1v2.n986 vss_1v2.n898 0.00981217
R8398 vss_1v2.n1031 vss_1v2.n530 0.00981217
R8399 vss_1v2.n982 vss_1v2.n902 0.00981217
R8400 vss_1v2.n1037 vss_1v2.n524 0.00981217
R8401 vss_1v2.n978 vss_1v2.n906 0.00981217
R8402 vss_1v2.n1041 vss_1v2.n520 0.00981217
R8403 vss_1v2.n972 vss_1v2.n912 0.00981217
R8404 vss_1v2.n968 vss_1v2.n916 0.00981217
R8405 vss_1v2.n1051 vss_1v2.n510 0.00981217
R8406 vss_1v2.n963 vss_1v2.n922 0.00981217
R8407 vss_1v2.n1055 vss_1v2.n506 0.00981217
R8408 vss_1v2.n959 vss_1v2.n926 0.00981217
R8409 vss_1v2.n1216 vss_1v2.n500 0.00981217
R8410 vss_1v2.n955 vss_1v2.n930 0.00981217
R8411 vss_1v2.n1219 vss_1v2.n496 0.00981217
R8412 vss_1v2.n3736 vss_1v2.n3735 0.00966667
R8413 vss_1v2.n450 vss_1v2.n449 0.00558086
R8414 vss_1v2.n2558 vss_1v2.n2557 0.00966667
R8415 vss_1v2.n447 vss_1v2.n446 0.00558086
R8416 vss_1v2.n2543 vss_1v2.n2542 0.00966667
R8417 vss_1v2.n3774 vss_1v2.n3773 0.00966667
R8418 vss_1v2.n3782 vss_1v2.n2527 0.00966667
R8419 vss_1v2.n3784 vss_1v2.n3783 0.00966667
R8420 vss_1v2.n3786 vss_1v2.n3785 0.00966667
R8421 vss_1v2.n3788 vss_1v2.n3787 0.00966667
R8422 vss_1v2.n3790 vss_1v2.n3789 0.00966667
R8423 vss_1v2.n3792 vss_1v2.n3791 0.00966667
R8424 vss_1v2.n3794 vss_1v2.n3793 0.00966667
R8425 vss_1v2.n3796 vss_1v2.n3795 0.00966667
R8426 vss_1v2.n3798 vss_1v2.n3797 0.00966667
R8427 vss_1v2.n3800 vss_1v2.n3799 0.00966667
R8428 vss_1v2.n3802 vss_1v2.n3801 0.00966667
R8429 vss_1v2.n3804 vss_1v2.n3803 0.00966667
R8430 vss_1v2.n3806 vss_1v2.n3805 0.00966667
R8431 vss_1v2.n3808 vss_1v2.n3807 0.00966667
R8432 vss_1v2.n3588 vss_1v2.n2662 0.00939094
R8433 vss_1v2.n1186 vss_1v2.n516 0.00923016
R8434 vss_1v2.n1076 vss_1v2.n1047 0.00923016
R8435 vss_1v2.n2546 vss_1v2.n2545 0.00908466
R8436 vss_1v2.n4025 vss_1v2.n4024 0.0088339
R8437 vss_1v2.n436 vss_1v2.n433 0.00864815
R8438 vss_1v2.n1018 vss_1v2.n874 0.00864815
R8439 vss_1v2.n998 vss_1v2.n554 0.00864815
R8440 vss_1v2.n1020 vss_1v2.n878 0.00864815
R8441 vss_1v2.n995 vss_1v2.n548 0.00864815
R8442 vss_1v2.n1022 vss_1v2.n882 0.00864815
R8443 vss_1v2.n993 vss_1v2.n544 0.00864815
R8444 vss_1v2.n1025 vss_1v2.n888 0.00864815
R8445 vss_1v2.n991 vss_1v2.n540 0.00864815
R8446 vss_1v2.n1027 vss_1v2.n892 0.00864815
R8447 vss_1v2.n988 vss_1v2.n534 0.00864815
R8448 vss_1v2.n1029 vss_1v2.n896 0.00864815
R8449 vss_1v2.n1080 vss_1v2.n976 0.00864815
R8450 vss_1v2.n1068 vss_1v2.n920 0.00864815
R8451 vss_1v2.n953 vss_1v2.n952 0.00864815
R8452 vss_1v2.n3776 vss_1v2.n2536 0.00864815
R8453 vss_1v2.n3330 vss_1v2.n3329 0.00860673
R8454 vss_1v2.n2642 vss_1v2.n2641 0.00850265
R8455 vss_1v2.n2639 vss_1v2.n2638 0.00850265
R8456 vss_1v2.n3657 vss_1v2.n3656 0.00850265
R8457 vss_1v2.n432 vss_1v2.n431 0.00499944
R8458 vss_1v2.n3671 vss_1v2.n3670 0.00850265
R8459 vss_1v2.n2622 vss_1v2.n2621 0.00850265
R8460 vss_1v2.n422 vss_1v2.n421 0.00499944
R8461 vss_1v2.n2610 vss_1v2.n2609 0.00850265
R8462 vss_1v2.n2607 vss_1v2.n2606 0.00850265
R8463 vss_1v2.n3695 vss_1v2.n3694 0.00850265
R8464 vss_1v2.n2596 vss_1v2.n2590 0.00850265
R8465 vss_1v2.n3707 vss_1v2.n3706 0.00850265
R8466 vss_1v2.n2588 vss_1v2.n2587 0.00850265
R8467 vss_1v2.n429 vss_1v2.n428 0.00499944
R8468 vss_1v2.n2576 vss_1v2.n2575 0.00850265
R8469 vss_1v2.n2574 vss_1v2.n2569 0.00850265
R8470 vss_1v2.n3750 vss_1v2.n3749 0.00850265
R8471 vss_1v2.n1463 vss_1v2.n572 0.00806614
R8472 vss_1v2.n1006 vss_1v2.n859 0.00806614
R8473 vss_1v2.n1013 vss_1v2.n568 0.00806614
R8474 vss_1v2.n1004 vss_1v2.n863 0.00806614
R8475 vss_1v2.n1015 vss_1v2.n564 0.00806614
R8476 vss_1v2.n1001 vss_1v2.n869 0.00806614
R8477 vss_1v2.n560 vss_1v2.n495 0.00806614
R8478 vss_1v2.n1017 vss_1v2.n558 0.00806614
R8479 vss_1v2.n999 vss_1v2.n872 0.00806614
R8480 vss_1v2.n1128 vss_1v2.n550 0.00806614
R8481 vss_1v2.n1097 vss_1v2.n990 0.00806614
R8482 vss_1v2.n1167 vss_1v2.n1033 0.00806614
R8483 vss_1v2.n1086 vss_1v2.n526 0.00806614
R8484 vss_1v2.n1061 vss_1v2.n1057 0.00806614
R8485 vss_1v2.n1213 vss_1v2.n502 0.00806614
R8486 vss_1v2.n3738 vss_1v2.n2568 0.00806614
R8487 vss_1v2.n4125 vss_1v2.n720 0.00805787
R8488 vss_1v2.n3345 vss_1v2.n3344 0.00799818
R8489 vss_1v2.n3504 vss_1v2.t20 0.00799818
R8490 vss_1v2.n3654 vss_1v2.n3653 0.00792063
R8491 vss_1v2.n3712 vss_1v2.n3711 0.00792063
R8492 vss_1v2.n3733 vss_1v2.n3732 0.00792063
R8493 vss_1v2.n468 vss_1v2.n396 0.00589909
R8494 vss_1v2.n416 vss_1v2.n415 0.00456332
R8495 vss_1v2.n1427 vss_1v2.n633 0.00762963
R8496 vss_1v2.n1365 vss_1v2.n798 0.00762963
R8497 vss_1v2.n404 vss_1v2.n403 0.00456332
R8498 vss_1v2.n1363 vss_1v2.n803 0.00762963
R8499 vss_1v2.n1430 vss_1v2.n626 0.00762963
R8500 vss_1v2.n1361 vss_1v2.n807 0.00762963
R8501 vss_1v2.n1433 vss_1v2.n620 0.00762963
R8502 vss_1v2.n1359 vss_1v2.n811 0.00762963
R8503 vss_1v2.n1358 vss_1v2.n813 0.00762963
R8504 vss_1v2.n1435 vss_1v2.n616 0.00762963
R8505 vss_1v2.n413 vss_1v2.n412 0.00456332
R8506 vss_1v2.n1437 vss_1v2.n611 0.00762963
R8507 vss_1v2.n1355 vss_1v2.n820 0.00762963
R8508 vss_1v2.n401 vss_1v2.n400 0.00456332
R8509 vss_1v2.n1353 vss_1v2.n825 0.00762963
R8510 vss_1v2.n1440 vss_1v2.n604 0.00762963
R8511 vss_1v2.n1351 vss_1v2.n829 0.00762963
R8512 vss_1v2.n1443 vss_1v2.n598 0.00762963
R8513 vss_1v2.n1349 vss_1v2.n833 0.00762963
R8514 vss_1v2.n1348 vss_1v2.n835 0.00762963
R8515 vss_1v2.n1445 vss_1v2.n594 0.00762963
R8516 vss_1v2.n410 vss_1v2.n409 0.00456332
R8517 vss_1v2.n1447 vss_1v2.n589 0.00762963
R8518 vss_1v2.n1345 vss_1v2.n842 0.00762963
R8519 vss_1v2.n398 vss_1v2.n397 0.00456332
R8520 vss_1v2.n1343 vss_1v2.n847 0.00762963
R8521 vss_1v2.n1450 vss_1v2.n582 0.00762963
R8522 vss_1v2.n1341 vss_1v2.n851 0.00762963
R8523 vss_1v2.n1453 vss_1v2.n576 0.00762963
R8524 vss_1v2.n1339 vss_1v2.n855 0.00762963
R8525 vss_1v2.n1338 vss_1v2.n857 0.00762963
R8526 vss_1v2.n1839 vss_1v2.n573 0.00762963
R8527 vss_1v2.n260 vss_1v2.n6 0.00554766
R8528 vss_1v2.n395 vss_1v2.n1968 0.00751392
R8529 vss_1v2.n4030 vss_1v2.n1975 0.00751392
R8530 vss_1v2.n3505 vss_1v2.n2868 0.00751392
R8531 vss_1v2.n3487 vss_1v2.n2900 0.00751392
R8532 vss_1v2.n425 vss_1v2.n308 0.00774604
R8533 vss_1v2.n1489 vss_1v2.n1012 0.00748413
R8534 vss_1v2.n1479 vss_1v2.n865 0.00748413
R8535 vss_1v2.n1138 vss_1v2.n1023 0.00748413
R8536 vss_1v2.n1103 vss_1v2.n886 0.00748413
R8537 vss_1v2.n1082 vss_1v2.n910 0.00748413
R8538 vss_1v2.n1196 vss_1v2.n966 0.00748413
R8539 vss_1v2.n3697 vss_1v2.n2600 0.00748413
R8540 vss_1v2.n2555 vss_1v2.n2554 0.00748413
R8541 vss_1v2.n3692 vss_1v2.n3691 0.00733862
R8542 vss_1v2.n3771 vss_1v2.n3770 0.00733862
R8543 vss_1v2.n3336 vss_1v2.n3219 0.00707343
R8544 vss_1v2.n3155 vss_1v2.n2986 0.00707343
R8545 vss_1v2.n3495 vss_1v2.n2886 0.00707343
R8546 vss_1v2.n3581 vss_1v2.n2679 0.00707343
R8547 vss_1v2.n1397 vss_1v2.n730 0.00704762
R8548 vss_1v2.n1395 vss_1v2.n698 0.00704762
R8549 vss_1v2.n1398 vss_1v2.n732 0.00704762
R8550 vss_1v2.n1394 vss_1v2.n696 0.00704762
R8551 vss_1v2.n1399 vss_1v2.n734 0.00704762
R8552 vss_1v2.n1393 vss_1v2.n694 0.00704762
R8553 vss_1v2.n1400 vss_1v2.n736 0.00704762
R8554 vss_1v2.n1392 vss_1v2.n692 0.00704762
R8555 vss_1v2.n1401 vss_1v2.n738 0.00704762
R8556 vss_1v2.n1391 vss_1v2.n690 0.00704762
R8557 vss_1v2.n1402 vss_1v2.n740 0.00704762
R8558 vss_1v2.n1390 vss_1v2.n688 0.00704762
R8559 vss_1v2.n386 vss_1v2.n385 0.00427255
R8560 vss_1v2.n1389 vss_1v2.n685 0.00704762
R8561 vss_1v2.n1404 vss_1v2.n745 0.00704762
R8562 vss_1v2.n1405 vss_1v2.n747 0.00704762
R8563 vss_1v2.n1387 vss_1v2.n681 0.00704762
R8564 vss_1v2.n1407 vss_1v2.n751 0.00704762
R8565 vss_1v2.n1385 vss_1v2.n677 0.00704762
R8566 vss_1v2.n1384 vss_1v2.n675 0.00704762
R8567 vss_1v2.n1409 vss_1v2.n755 0.00704762
R8568 vss_1v2.n393 vss_1v2.n392 0.00427255
R8569 vss_1v2.n1411 vss_1v2.n760 0.00704762
R8570 vss_1v2.n1381 vss_1v2.n668 0.00704762
R8571 vss_1v2.n383 vss_1v2.n382 0.00427255
R8572 vss_1v2.n1379 vss_1v2.n663 0.00704762
R8573 vss_1v2.n1414 vss_1v2.n767 0.00704762
R8574 vss_1v2.n1415 vss_1v2.n769 0.00704762
R8575 vss_1v2.n1377 vss_1v2.n659 0.00704762
R8576 vss_1v2.n1417 vss_1v2.n773 0.00704762
R8577 vss_1v2.n1375 vss_1v2.n655 0.00704762
R8578 vss_1v2.n1374 vss_1v2.n653 0.00704762
R8579 vss_1v2.n1419 vss_1v2.n777 0.00704762
R8580 vss_1v2.n390 vss_1v2.n389 0.00427255
R8581 vss_1v2.n1421 vss_1v2.n782 0.00704762
R8582 vss_1v2.n1371 vss_1v2.n646 0.00704762
R8583 vss_1v2.n380 vss_1v2.n379 0.00427255
R8584 vss_1v2.n1369 vss_1v2.n641 0.00704762
R8585 vss_1v2.n1424 vss_1v2.n789 0.00704762
R8586 vss_1v2.n1425 vss_1v2.n791 0.00704762
R8587 vss_1v2.n1367 vss_1v2.n638 0.00704762
R8588 vss_1v2.n1740 vss_1v2.n1431 0.00704762
R8589 vss_1v2.n1526 vss_1v2.n1441 0.00704762
R8590 vss_1v2.n1507 vss_1v2.n1451 0.00704762
R8591 vss_1v2.n1396 vss_1v2.n700 0.00704762
R8592 vss_1v2.n1548 vss_1v2.n622 0.00690212
R8593 vss_1v2.n1528 vss_1v2.n600 0.00690212
R8594 vss_1v2.n1827 vss_1v2.n578 0.00690212
R8595 vss_1v2.n1461 vss_1v2.n572 0.00690212
R8596 vss_1v2.n1477 vss_1v2.n1002 0.00690212
R8597 vss_1v2.n1126 vss_1v2.n997 0.00690212
R8598 vss_1v2.n1099 vss_1v2.n536 0.00690212
R8599 vss_1v2.n1184 vss_1v2.n1043 0.00690212
R8600 vss_1v2.n1194 vss_1v2.n512 0.00690212
R8601 vss_1v2.n3659 vss_1v2.n2631 0.00690212
R8602 vss_1v2.n2585 vss_1v2.n2584 0.00690212
R8603 vss_1v2.n3769 vss_1v2.n3768 0.00690212
R8604 vss_1v2.n3346 vss_1v2.n3345 0.00683888
R8605 vss_1v2.n4129 vss_1v2.n4120 0.0068308
R8606 vss_1v2.n4129 vss_1v2.n1881 0.00682905
R8607 vss_1v2.n3 vss_1v2.n2 0.209851
R8608 vss_1v2.n3328 vss_1v2.n3327 0.00676909
R8609 vss_1v2.n3679 vss_1v2.n2612 0.00675661
R8610 vss_1v2.n3758 vss_1v2.n2548 0.00675661
R8611 vss_1v2.n3210 vss_1v2.n3209 0.00673876
R8612 vss_1v2.n3640 vss_1v2.n938 0.00661111
R8613 vss_1v2.n1604 vss_1v2.n1380 0.00646561
R8614 vss_1v2.n1702 vss_1v2.n1370 0.00646561
R8615 vss_1v2.n1729 vss_1v2.n1364 0.00646561
R8616 vss_1v2.n1769 vss_1v2.n1354 0.00646561
R8617 vss_1v2.n1511 vss_1v2.n1344 0.00646561
R8618 vss_1v2.n1635 vss_1v2.n749 0.00632011
R8619 vss_1v2.n1675 vss_1v2.n771 0.00632011
R8620 vss_1v2.n1566 vss_1v2.n793 0.00632011
R8621 vss_1v2.n1544 vss_1v2.n815 0.00632011
R8622 vss_1v2.n1797 vss_1v2.n837 0.00632011
R8623 vss_1v2.n1498 vss_1v2.n433 0.00632011
R8624 vss_1v2.n1116 vss_1v2.n876 0.00632011
R8625 vss_1v2.n1156 vss_1v2.n1028 0.00632011
R8626 vss_1v2.n1092 vss_1v2.n896 0.00632011
R8627 vss_1v2.n1165 vss_1v2.n900 0.00632011
R8628 vss_1v2.n1088 vss_1v2.n980 0.00632011
R8629 vss_1v2.n1205 vss_1v2.n924 0.00632011
R8630 vss_1v2.n1059 vss_1v2.n957 0.00632011
R8631 vss_1v2.n2619 vss_1v2.n2618 0.00632011
R8632 vss_1v2.n3731 vss_1v2.n3730 0.00632011
R8633 vss_1v2.n4106 vss_1v2.n4105 0.00632011
R8634 vss_1v2.n2630 vss_1v2.n2629 0.0061746
R8635 vss_1v2.n3720 vss_1v2.n2578 0.0061746
R8636 vss_1v2.n2567 vss_1v2.n2566 0.0061746
R8637 vss_1v2.n1608 vss_1v2.n1410 0.0058836
R8638 vss_1v2.n1586 vss_1v2.n1420 0.0058836
R8639 vss_1v2.n1568 vss_1v2.n1426 0.0058836
R8640 vss_1v2.n1758 vss_1v2.n1436 0.0058836
R8641 vss_1v2.n1799 vss_1v2.n1446 0.0058836
R8642 vss_1v2.n3504 vss_1v2.n2880 0.00585986
R8643 vss_1v2.n1856 vss_1v2.n720 0.00582476
R8644 vss_1v2.n1647 vss_1v2.n673 0.0057381
R8645 vss_1v2.n1584 vss_1v2.n651 0.0057381
R8646 vss_1v2.n1562 vss_1v2.n631 0.0057381
R8647 vss_1v2.n1767 vss_1v2.n609 0.0057381
R8648 vss_1v2.n1809 vss_1v2.n587 0.0057381
R8649 vss_1v2.n1473 vss_1v2.n562 0.0057381
R8650 vss_1v2.n1136 vss_1v2.n546 0.0057381
R8651 vss_1v2.n1105 vss_1v2.n992 0.0057381
R8652 vss_1v2.n1176 vss_1v2.n522 0.0057381
R8653 vss_1v2.n1070 vss_1v2.n1053 0.0057381
R8654 vss_1v2.n4137 vss_1v2.n498 0.0057381
R8655 vss_1v2.n3690 vss_1v2.n3689 0.0057381
R8656 vss_1v2.n3748 vss_1v2.n3747 0.0057381
R8657 vss_1v2.n3162 vss_1v2.n2980 0.00567482
R8658 vss_1v2.n3643 vss_1v2.n3642 0.00559259
R8659 vss_1v2.n2599 vss_1v2.n2598 0.00559259
R8660 vss_1v2.n2535 vss_1v2.n2534 0.00559259
R8661 vss_1v2.n3327 vss_1v2.n3326 0.00555076
R8662 vss_1v2.n1940 vss_1v2.n45 0.0140395
R8663 vss_1v2.n2863 vss_1v2.n2861 0.00531563
R8664 vss_1v2.n1637 vss_1v2.n1386 0.00530159
R8665 vss_1v2.n1590 vss_1v2.n1376 0.00530159
R8666 vss_1v2.n1550 vss_1v2.n1360 0.00530159
R8667 vss_1v2.n1787 vss_1v2.n1350 0.00530159
R8668 vss_1v2.n1829 vss_1v2.n1340 0.00530159
R8669 vss_1v2.n2661 vss_1v2.n2663 0.00525524
R8670 vss_1v2.n3334 vss_1v2.n3333 0.00525524
R8671 vss_1v2.n3339 vss_1v2.n3338 0.00525524
R8672 vss_1v2.n3343 vss_1v2.n3342 0.00525524
R8673 vss_1v2.n3160 vss_1v2.n3158 0.00525524
R8674 vss_1v2.n3153 vss_1v2.n3152 0.00525524
R8675 vss_1v2.n3499 vss_1v2.n3497 0.00525524
R8676 vss_1v2.n2883 vss_1v2.n3502 0.00525524
R8677 vss_1v2.n3574 vss_1v2.n3572 0.00525524
R8678 vss_1v2.n3582 vss_1v2.n2681 0.00525524
R8679 vss_1v2.n408 vss_1v2.n407 0.00525524
R8680 vss_1v2.n4112 vss_1v2.n4111 0.00521429
R8681 vss_1v2.n3150 vss_1v2.n3149 0.00519514
R8682 vss_1v2.n3565 vss_1v2.n2813 0.00519514
R8683 vss_1v2.n4027 vss_1v2.n4026 0.00519514
R8684 vss_1v2.n4023 vss_1v2.n468 0.00814429
R8685 vss_1v2.n3490 vss_1v2.n353 0.00518531
R8686 vss_1v2.n1602 vss_1v2.n762 0.00515608
R8687 vss_1v2.n1580 vss_1v2.n784 0.00515608
R8688 vss_1v2.n1738 vss_1v2.n805 0.00515608
R8689 vss_1v2.n1779 vss_1v2.n827 0.00515608
R8690 vss_1v2.n1505 vss_1v2.n849 0.00515608
R8691 vss_1v2.n1487 vss_1v2.n861 0.00515608
R8692 vss_1v2.n1467 vss_1v2.n1014 0.00515608
R8693 vss_1v2.n1109 vss_1v2.n1021 0.00515608
R8694 vss_1v2.n1148 vss_1v2.n890 0.00515608
R8695 vss_1v2.n1074 vss_1v2.n970 0.00515608
R8696 vss_1v2.n1074 vss_1v2.n914 0.00515608
R8697 vss_1v2.n3652 vss_1v2.n3651 0.00515608
R8698 vss_1v2.n3710 vss_1v2.n3709 0.00515608
R8699 vss_1v2.n3760 vss_1v2.n2547 0.00515608
R8700 vss_1v2.n3681 vss_1v2.n3680 0.00501058
R8701 vss_1v2.n3760 vss_1v2.n3759 0.00501058
R8702 vss_1v2.n4147 vss_1v2.n4146 0.00486508
R8703 vss_1v2.n3149 vss_1v2.n3148 0.00484549
R8704 vss_1v2.n3493 vss_1v2.n3491 0.00484549
R8705 vss_1v2.n3565 vss_1v2.n3564 0.00484549
R8706 vss_1v2.n4028 vss_1v2.n4027 0.00484549
R8707 vss_1v2.n2858 vss_1v2.n935 0.00483623
R8708 vss_1v2.n1625 vss_1v2.n1403 0.00471958
R8709 vss_1v2.n1666 vss_1v2.n1413 0.00471958
R8710 vss_1v2.n1572 vss_1v2.n1423 0.00471958
R8711 vss_1v2.n1554 vss_1v2.n1429 0.00471958
R8712 vss_1v2.n1533 vss_1v2.n1439 0.00471958
R8713 vss_1v2.n1817 vss_1v2.n1449 0.00471958
R8714 vss_1v2.n3326 vss_1v2.n3325 0.00462587
R8715 vss_1v2.n2522 vss_1v2.n2511 0.00461318
R8716 vss_1v2.n41 vss_1v2.n1221 0.466861
R8717 vss_1v2.n1619 vss_1v2.n683 0.00457407
R8718 vss_1v2.n1598 vss_1v2.n661 0.00457407
R8719 vss_1v2.n1711 vss_1v2.n639 0.00457407
R8720 vss_1v2.n1566 vss_1v2.n638 0.00457407
R8721 vss_1v2.n1750 vss_1v2.n618 0.00457407
R8722 vss_1v2.n1521 vss_1v2.n596 0.00457407
R8723 vss_1v2.n1837 vss_1v2.n575 0.00457407
R8724 vss_1v2.n1498 vss_1v2.n573 0.00457407
R8725 vss_1v2.n4149 vss_1v2.n494 0.00457407
R8726 vss_1v2.n1118 vss_1v2.n999 0.00457407
R8727 vss_1v2.n1118 vss_1v2.n556 0.00457407
R8728 vss_1v2.n1092 vss_1v2.n532 0.00457407
R8729 vss_1v2.n1176 vss_1v2.n1039 0.00457407
R8730 vss_1v2.n1070 vss_1v2.n508 0.00457407
R8731 vss_1v2.n4137 vss_1v2.n4136 0.00457407
R8732 vss_1v2.n3669 vss_1v2.n3668 0.00457407
R8733 vss_1v2.n3722 vss_1v2.n2577 0.00457407
R8734 vss_1v2.n3730 vss_1v2.n2569 0.00457407
R8735 vss_1v2.n2534 vss_1v2.n2533 0.00457407
R8736 vss_1v2.n3835 vss_1v2.n3817 0.00443058
R8737 vss_1v2.n3668 vss_1v2.n3667 0.00442857
R8738 vss_1v2.n3722 vss_1v2.n3721 0.00442857
R8739 vss_1v2.n3747 vss_1v2.n3746 0.00442857
R8740 vss_1v2.n4118 vss_1v2.n47 0.0614563
R8741 vss_1v2.n3639 vss_1v2.n2644 0.00435539
R8742 vss_1v2.n3629 vss_1v2.n2644 0.00435539
R8743 vss_1v2.n3817 vss_1v2.n3816 0.00431827
R8744 vss_1v2.n3816 vss_1v2.n3814 0.00431827
R8745 vss_1v2.n3814 vss_1v2.n3813 0.00431827
R8746 vss_1v2.n3813 vss_1v2.n3812 0.00431827
R8747 vss_1v2.n3812 vss_1v2.n3811 0.00431827
R8748 vss_1v2.n375 vss_1v2.n374 0.00431827
R8749 vss_1v2.n3389 vss_1v2.n467 0.00431827
R8750 vss_1v2.n3390 vss_1v2.n3389 0.00431827
R8751 vss_1v2.n3391 vss_1v2.n3390 0.00431827
R8752 vss_1v2.n2966 vss_1v2.n2960 0.00431827
R8753 vss_1v2.n3429 vss_1v2.n478 0.00431827
R8754 vss_1v2.n3441 vss_1v2.n455 0.00431827
R8755 vss_1v2.n3457 vss_1v2.n2948 0.00431827
R8756 vss_1v2.n374 vss_1v2.n481 0.00431827
R8757 vss_1v2.n45 vss_1v2.n355 0.00953666
R8758 vss_1v2.n3834 vss_1v2.n2522 0.00421179
R8759 vss_1v2.n84 vss_1v2.n442 0.0028225
R8760 vss_1v2.n443 vss_1v2.n51 0.00537251
R8761 vss_1v2.n1655 vss_1v2.n1382 0.00413757
R8762 vss_1v2.n1694 vss_1v2.n1372 0.00413757
R8763 vss_1v2.n1721 vss_1v2.n1366 0.00413757
R8764 vss_1v2.n1537 vss_1v2.n1356 0.00413757
R8765 vss_1v2.n1517 vss_1v2.n1346 0.00413757
R8766 vss_1v2.n3067 vss_1v2.n3066 0.00413636
R8767 vss_1v2.n3376 vss_1v2.n473 0.00409367
R8768 vss_1v2.n1615 vss_1v2.n753 0.00399206
R8769 vss_1v2.n1683 vss_1v2.n775 0.00399206
R8770 vss_1v2.n1721 vss_1v2.n796 0.00399206
R8771 vss_1v2.n1537 vss_1v2.n818 0.00399206
R8772 vss_1v2.n1517 vss_1v2.n840 0.00399206
R8773 vss_1v2.n4149 vss_1v2.n4148 0.00399206
R8774 vss_1v2.n1109 vss_1v2.n880 0.00399206
R8775 vss_1v2.n1148 vss_1v2.n1026 0.00399206
R8776 vss_1v2.n1165 vss_1v2.n984 0.00399206
R8777 vss_1v2.n1088 vss_1v2.n904 0.00399206
R8778 vss_1v2.n1205 vss_1v2.n961 0.00399206
R8779 vss_1v2.n1059 vss_1v2.n928 0.00399206
R8780 vss_1v2.n3681 vss_1v2.n2611 0.00399206
R8781 vss_1v2.n2566 vss_1v2.n2565 0.00399206
R8782 vss_1v2.n424 vss_1v2.n423 0.00398137
R8783 vss_1v2.n3147 vss_1v2.n2902 0.00392657
R8784 vss_1v2.n3563 vss_1v2.n1969 0.00385664
R8785 vss_1v2.n1397 vss_1v2.n700 0.00384656
R8786 vss_1v2.n1395 vss_1v2.n730 0.00384656
R8787 vss_1v2.n1398 vss_1v2.n698 0.00384656
R8788 vss_1v2.n1394 vss_1v2.n732 0.00384656
R8789 vss_1v2.n1399 vss_1v2.n696 0.00384656
R8790 vss_1v2.n1393 vss_1v2.n734 0.00384656
R8791 vss_1v2.n1400 vss_1v2.n694 0.00384656
R8792 vss_1v2.n1392 vss_1v2.n736 0.00384656
R8793 vss_1v2.n1401 vss_1v2.n692 0.00384656
R8794 vss_1v2.n1391 vss_1v2.n738 0.00384656
R8795 vss_1v2.n1402 vss_1v2.n690 0.00384656
R8796 vss_1v2.n1390 vss_1v2.n740 0.00384656
R8797 vss_1v2.n386 vss_1v2.n688 0.00761911
R8798 vss_1v2.n1403 vss_1v2.n387 0.00928934
R8799 vss_1v2.n1389 vss_1v2.n743 0.00384656
R8800 vss_1v2.n1388 vss_1v2.n745 0.00384656
R8801 vss_1v2.n1405 vss_1v2.n683 0.00384656
R8802 vss_1v2.n1387 vss_1v2.n747 0.00384656
R8803 vss_1v2.n1406 vss_1v2.n681 0.00384656
R8804 vss_1v2.n1386 vss_1v2.n749 0.00384656
R8805 vss_1v2.n1407 vss_1v2.n679 0.00384656
R8806 vss_1v2.n1408 vss_1v2.n677 0.00384656
R8807 vss_1v2.n1384 vss_1v2.n753 0.00384656
R8808 vss_1v2.n1383 vss_1v2.n755 0.00384656
R8809 vss_1v2.n1410 vss_1v2.n673 0.00384656
R8810 vss_1v2.n393 vss_1v2.n757 0.00761911
R8811 vss_1v2.n1382 vss_1v2.n394 0.00928934
R8812 vss_1v2.n1411 vss_1v2.n670 0.00384656
R8813 vss_1v2.n1412 vss_1v2.n668 0.00384656
R8814 vss_1v2.n1380 vss_1v2.n762 0.00384656
R8815 vss_1v2.n383 vss_1v2.n666 0.00761911
R8816 vss_1v2.n1413 vss_1v2.n384 0.00928934
R8817 vss_1v2.n1379 vss_1v2.n765 0.00384656
R8818 vss_1v2.n1378 vss_1v2.n767 0.00384656
R8819 vss_1v2.n1415 vss_1v2.n661 0.00384656
R8820 vss_1v2.n1377 vss_1v2.n769 0.00384656
R8821 vss_1v2.n1416 vss_1v2.n659 0.00384656
R8822 vss_1v2.n1376 vss_1v2.n771 0.00384656
R8823 vss_1v2.n1417 vss_1v2.n657 0.00384656
R8824 vss_1v2.n1418 vss_1v2.n655 0.00384656
R8825 vss_1v2.n1374 vss_1v2.n775 0.00384656
R8826 vss_1v2.n1373 vss_1v2.n777 0.00384656
R8827 vss_1v2.n1420 vss_1v2.n651 0.00384656
R8828 vss_1v2.n390 vss_1v2.n779 0.00761911
R8829 vss_1v2.n1372 vss_1v2.n391 0.00928934
R8830 vss_1v2.n1421 vss_1v2.n648 0.00384656
R8831 vss_1v2.n1422 vss_1v2.n646 0.00384656
R8832 vss_1v2.n1370 vss_1v2.n784 0.00384656
R8833 vss_1v2.n380 vss_1v2.n644 0.00761911
R8834 vss_1v2.n1423 vss_1v2.n381 0.00928934
R8835 vss_1v2.n1369 vss_1v2.n787 0.00384656
R8836 vss_1v2.n1368 vss_1v2.n789 0.00384656
R8837 vss_1v2.n1425 vss_1v2.n639 0.00384656
R8838 vss_1v2.n1367 vss_1v2.n791 0.00384656
R8839 vss_1v2.n3651 vss_1v2.n2632 0.00384656
R8840 vss_1v2.n3709 vss_1v2.n3708 0.00384656
R8841 vss_1v2.n1396 vss_1v2.n728 0.00384656
R8842 vss_1v2.n3057 vss_1v2.n1870 0.00380399
R8843 vss_1v2.n3163 vss_1v2.n3162 0.00378671
R8844 vss_1v2.n3148 vss_1v2.n3147 0.00378671
R8845 vss_1v2.n3491 vss_1v2.n3490 0.00378671
R8846 vss_1v2.n3066 vss_1v2.n2690 0.00378671
R8847 vss_1v2.n3564 vss_1v2.n3563 0.00378671
R8848 vss_1v2.n407 vss_1v2.n4028 0.00378671
R8849 vss_1v2.n2909 vss_1v2.n2908 0.00375676
R8850 vss_1v2.n3358 vss_1v2.n370 0.00564156
R8851 vss_1v2.n3362 vss_1v2.n3360 0.00364446
R8852 vss_1v2.n3363 vss_1v2.n3357 0.00364446
R8853 vss_1v2.n3357 vss_1v2.n3355 0.00364446
R8854 vss_1v2.n3371 vss_1v2.n3353 0.00364446
R8855 vss_1v2.n3378 vss_1v2.n3376 0.00364446
R8856 vss_1v2.n3380 vss_1v2.n3379 0.00364446
R8857 vss_1v2.n3385 vss_1v2.n3383 0.00364446
R8858 vss_1v2.n3387 vss_1v2.n3386 0.00364446
R8859 vss_1v2.n3462 vss_1v2.n3461 0.00364446
R8860 vss_1v2.n3464 vss_1v2.n3460 0.00364446
R8861 vss_1v2.n3468 vss_1v2.n3466 0.00364446
R8862 vss_1v2.n1932 vss_1v2.n1866 0.00357613
R8863 vss_1v2.n360 vss_1v2.n358 0.00253765
R8864 vss_1v2.n1935 vss_1v2.n359 0.00357613
R8865 vss_1v2.n1936 vss_1v2.n1867 0.00357613
R8866 vss_1v2.n3109 vss_1v2.n1845 0.00357613
R8867 vss_1v2.n1615 vss_1v2.n1408 0.00355556
R8868 vss_1v2.n1683 vss_1v2.n1418 0.00355556
R8869 vss_1v2.n1750 vss_1v2.n1434 0.00355556
R8870 vss_1v2.n1521 vss_1v2.n1444 0.00355556
R8871 vss_1v2.n1838 vss_1v2.n1837 0.00355556
R8872 vss_1v2.n2876 vss_1v2.n2869 0.00353216
R8873 vss_1v2.n3056 vss_1v2.n1844 0.0034622
R8874 vss_1v2.n3055 vss_1v2.n1871 0.0034622
R8875 vss_1v2.n1946 vss_1v2.n362 0.0034622
R8876 vss_1v2.n363 vss_1v2.n361 0.00248071
R8877 vss_1v2.n3589 vss_1v2.n3588 0.00344689
R8878 vss_1v2.n483 vss_1v2.n3493 0.00344689
R8879 vss_1v2.n3336 vss_1v2.n3335 0.00343706
R8880 vss_1v2.n3340 vss_1v2.n3339 0.00343706
R8881 vss_1v2.n3156 vss_1v2.n3155 0.00343706
R8882 vss_1v2.n3152 vss_1v2.n3150 0.00343706
R8883 vss_1v2.n3500 vss_1v2.n3499 0.00343706
R8884 vss_1v2.n3575 vss_1v2.n2679 0.00343706
R8885 vss_1v2.n2813 vss_1v2.n2681 0.00343706
R8886 vss_1v2.n2968 vss_1v2.n2966 0.00341986
R8887 vss_1v2.n2971 vss_1v2.n2969 0.00341986
R8888 vss_1v2.n2964 vss_1v2.n2963 0.00341986
R8889 vss_1v2.n2961 vss_1v2.n2904 0.00341986
R8890 vss_1v2.n1655 vss_1v2.n670 0.00341005
R8891 vss_1v2.n1694 vss_1v2.n648 0.00341005
R8892 vss_1v2.n1554 vss_1v2.n628 0.00341005
R8893 vss_1v2.n1533 vss_1v2.n606 0.00341005
R8894 vss_1v2.n1817 vss_1v2.n584 0.00341005
R8895 vss_1v2.n1487 vss_1v2.n1005 0.00341005
R8896 vss_1v2.n1467 vss_1v2.n566 0.00341005
R8897 vss_1v2.n1136 vss_1v2.n994 0.00341005
R8898 vss_1v2.n1105 vss_1v2.n542 0.00341005
R8899 vss_1v2.n1184 vss_1v2.n518 0.00341005
R8900 vss_1v2.n1194 vss_1v2.n1049 0.00341005
R8901 vss_1v2.n3643 vss_1v2.n2643 0.00341005
R8902 vss_1v2.n2598 vss_1v2.n2597 0.00341005
R8903 vss_1v2.n445 vss_1v2.n3758 0.00341005
R8904 vss_1v2.n2119 vss_1v2.n2118 0.00330756
R8905 vss_1v2.n1645 vss_1v2.n1409 0.00326455
R8906 vss_1v2.n1685 vss_1v2.n1419 0.00326455
R8907 vss_1v2.n1426 vss_1v2.n793 0.00326455
R8908 vss_1v2.n416 vss_1v2.n636 0.00732787
R8909 vss_1v2.n1366 vss_1v2.n417 0.00870732
R8910 vss_1v2.n1427 vss_1v2.n796 0.00326455
R8911 vss_1v2.n1428 vss_1v2.n798 0.00326455
R8912 vss_1v2.n1364 vss_1v2.n631 0.00326455
R8913 vss_1v2.n404 vss_1v2.n800 0.00732787
R8914 vss_1v2.n1429 vss_1v2.n405 0.00870732
R8915 vss_1v2.n1363 vss_1v2.n628 0.00326455
R8916 vss_1v2.n1362 vss_1v2.n626 0.00326455
R8917 vss_1v2.n1431 vss_1v2.n805 0.00326455
R8918 vss_1v2.n1361 vss_1v2.n624 0.00326455
R8919 vss_1v2.n1432 vss_1v2.n807 0.00326455
R8920 vss_1v2.n1360 vss_1v2.n622 0.00326455
R8921 vss_1v2.n1433 vss_1v2.n809 0.00326455
R8922 vss_1v2.n1434 vss_1v2.n811 0.00326455
R8923 vss_1v2.n1358 vss_1v2.n618 0.00326455
R8924 vss_1v2.n1435 vss_1v2.n813 0.00326455
R8925 vss_1v2.n1357 vss_1v2.n616 0.00326455
R8926 vss_1v2.n1436 vss_1v2.n815 0.00326455
R8927 vss_1v2.n413 vss_1v2.n614 0.00732787
R8928 vss_1v2.n1356 vss_1v2.n414 0.00870732
R8929 vss_1v2.n1437 vss_1v2.n818 0.00326455
R8930 vss_1v2.n1438 vss_1v2.n820 0.00326455
R8931 vss_1v2.n1354 vss_1v2.n609 0.00326455
R8932 vss_1v2.n401 vss_1v2.n822 0.00732787
R8933 vss_1v2.n1439 vss_1v2.n402 0.00870732
R8934 vss_1v2.n1353 vss_1v2.n606 0.00326455
R8935 vss_1v2.n1352 vss_1v2.n604 0.00326455
R8936 vss_1v2.n1441 vss_1v2.n827 0.00326455
R8937 vss_1v2.n1351 vss_1v2.n602 0.00326455
R8938 vss_1v2.n1442 vss_1v2.n829 0.00326455
R8939 vss_1v2.n1350 vss_1v2.n600 0.00326455
R8940 vss_1v2.n1443 vss_1v2.n831 0.00326455
R8941 vss_1v2.n1444 vss_1v2.n833 0.00326455
R8942 vss_1v2.n1348 vss_1v2.n596 0.00326455
R8943 vss_1v2.n1445 vss_1v2.n835 0.00326455
R8944 vss_1v2.n1347 vss_1v2.n594 0.00326455
R8945 vss_1v2.n1446 vss_1v2.n837 0.00326455
R8946 vss_1v2.n410 vss_1v2.n592 0.00732787
R8947 vss_1v2.n1346 vss_1v2.n411 0.00870732
R8948 vss_1v2.n1447 vss_1v2.n840 0.00326455
R8949 vss_1v2.n1448 vss_1v2.n842 0.00326455
R8950 vss_1v2.n1344 vss_1v2.n587 0.00326455
R8951 vss_1v2.n398 vss_1v2.n844 0.00732787
R8952 vss_1v2.n1449 vss_1v2.n399 0.00870732
R8953 vss_1v2.n1343 vss_1v2.n584 0.00326455
R8954 vss_1v2.n1342 vss_1v2.n582 0.00326455
R8955 vss_1v2.n1451 vss_1v2.n849 0.00326455
R8956 vss_1v2.n1341 vss_1v2.n580 0.00326455
R8957 vss_1v2.n1452 vss_1v2.n851 0.00326455
R8958 vss_1v2.n1340 vss_1v2.n578 0.00326455
R8959 vss_1v2.n1453 vss_1v2.n853 0.00326455
R8960 vss_1v2.n1838 vss_1v2.n855 0.00326455
R8961 vss_1v2.n1338 vss_1v2.n575 0.00326455
R8962 vss_1v2.n1839 vss_1v2.n857 0.00326455
R8963 vss_1v2.n3689 vss_1v2.n2601 0.00326455
R8964 vss_1v2.n3768 vss_1v2.n2537 0.00326455
R8965 vss_1v2.n2999 vss_1v2.n1864 0.00323433
R8966 vss_1v2.n1928 vss_1v2.n1847 0.00323433
R8967 vss_1v2.n1929 vss_1v2.n1865 0.00323433
R8968 vss_1v2.n3430 vss_1v2.n3429 0.00319525
R8969 vss_1v2.n3432 vss_1v2.n3431 0.00319525
R8970 vss_1v2.n3398 vss_1v2.n3396 0.00319525
R8971 vss_1v2.t349 vss_1v2.n2877 0.00319525
R8972 vss_1v2.n84 vss_1v2.n1869 0.00548652
R8973 vss_1v2.n1941 vss_1v2.n1872 0.0031204
R8974 vss_1v2.n1942 vss_1v2.n1873 0.0031204
R8975 vss_1v2.n1949 vss_1v2.n1842 0.0031204
R8976 vss_1v2.n1950 vss_1v2.n1874 0.0031204
R8977 vss_1v2.n365 vss_1v2.n211 0.0031204
R8978 vss_1v2.n4146 vss_1v2.n4145 0.00311905
R8979 vss_1v2.n3325 vss_1v2.n3324 0.00308741
R8980 vss_1v2.n1939 vss_1v2.n1869 0.00305009
R8981 vss_1v2.n1619 vss_1v2.n1388 0.00297355
R8982 vss_1v2.n1598 vss_1v2.n1378 0.00297355
R8983 vss_1v2.n1711 vss_1v2.n1368 0.00297355
R8984 vss_1v2.n1738 vss_1v2.n1362 0.00297355
R8985 vss_1v2.n1779 vss_1v2.n1352 0.00297355
R8986 vss_1v2.n1505 vss_1v2.n1342 0.00297355
R8987 vss_1v2.n3443 vss_1v2.n3441 0.00297065
R8988 vss_1v2.n3446 vss_1v2.n3444 0.00297065
R8989 vss_1v2.n3438 vss_1v2.n3437 0.00297065
R8990 vss_1v2.n3435 vss_1v2.n1970 0.00297065
R8991 vss_1v2.n2863 vss_1v2.n2858 0.00291803
R8992 vss_1v2.n3346 vss_1v2.n2980 0.00287762
R8993 vss_1v2.n2879 vss_1v2.n2878 0.00287762
R8994 vss_1v2.n2977 vss_1v2.n2960 0.00285835
R8995 vss_1v2.n3471 vss_1v2.n3470 0.00285835
R8996 vss_1v2.n1625 vss_1v2.n743 0.00282804
R8997 vss_1v2.n1613 vss_1v2.n751 0.00282804
R8998 vss_1v2.n1666 vss_1v2.n765 0.00282804
R8999 vss_1v2.n1592 vss_1v2.n773 0.00282804
R9000 vss_1v2.n1572 vss_1v2.n787 0.00282804
R9001 vss_1v2.n1550 vss_1v2.n809 0.00282804
R9002 vss_1v2.n1787 vss_1v2.n831 0.00282804
R9003 vss_1v2.n1829 vss_1v2.n853 0.00282804
R9004 vss_1v2.n1463 vss_1v2.n434 0.00819819
R9005 vss_1v2.n3811 vss_1v2.n371 0.00813655
R9006 vss_1v2.n437 vss_1v2.n375 0.00813655
R9007 vss_1v2.n2907 vss_1v2.n373 0.00791194
R9008 vss_1v2.n436 vss_1v2.n434 0.00776168
R9009 vss_1v2.n1011 vss_1v2.n859 0.00282804
R9010 vss_1v2.n1006 vss_1v2.n570 0.00282804
R9011 vss_1v2.n1012 vss_1v2.n861 0.00282804
R9012 vss_1v2.n1005 vss_1v2.n568 0.00282804
R9013 vss_1v2.n1004 vss_1v2.n566 0.00282804
R9014 vss_1v2.n1014 vss_1v2.n865 0.00282804
R9015 vss_1v2.n1003 vss_1v2.n564 0.00282804
R9016 vss_1v2.n1015 vss_1v2.n867 0.00282804
R9017 vss_1v2.n1002 vss_1v2.n562 0.00282804
R9018 vss_1v2.n1473 vss_1v2.n1016 0.00282804
R9019 vss_1v2.n1016 vss_1v2.n869 0.00282804
R9020 vss_1v2.n4148 vss_1v2.n495 0.00282804
R9021 vss_1v2.n558 vss_1v2.n494 0.00282804
R9022 vss_1v2.n1017 vss_1v2.n872 0.00282804
R9023 vss_1v2.n1116 vss_1v2.n1019 0.00282804
R9024 vss_1v2.n1156 vss_1v2.n894 0.00282804
R9025 vss_1v2.n1082 vss_1v2.n974 0.00282804
R9026 vss_1v2.n1196 vss_1v2.n918 0.00282804
R9027 vss_1v2.n4145 vss_1v2.n940 0.00282804
R9028 vss_1v2.n2629 vss_1v2.n2628 0.00282804
R9029 vss_1v2.n427 vss_1v2.n3720 0.00282804
R9030 vss_1v2.n3772 vss_1v2.n3771 0.00282804
R9031 vss_1v2.n35 vss_1v2.n354 0.00308745
R9032 vss_1v2.n366 vss_1v2.n364 0.00213908
R9033 vss_1v2.n3473 vss_1v2.n2948 0.00274604
R9034 vss_1v2.n3476 vss_1v2.n3474 0.00274604
R9035 vss_1v2.n2946 vss_1v2.n2945 0.00274604
R9036 vss_1v2.n4018 vss_1v2.n2000 0.00274068
R9037 vss_1v2.n1657 vss_1v2.n1381 0.00268254
R9038 vss_1v2.n1578 vss_1v2.n1371 0.00268254
R9039 vss_1v2.n1560 vss_1v2.n1365 0.00268254
R9040 vss_1v2.n1539 vss_1v2.n1355 0.00268254
R9041 vss_1v2.n1807 vss_1v2.n1345 0.00268254
R9042 vss_1v2.n2620 vss_1v2.n2619 0.00268254
R9043 vss_1v2.n2556 vss_1v2.n2555 0.00268254
R9044 vss_1v2.n3324 vss_1v2.n2663 0.00266783
R9045 vss_1v2.n1857 vss_1v2.n1852 0.00266468
R9046 vss_1v2.n1914 vss_1v2.n1859 0.00266468
R9047 vss_1v2.n1913 vss_1v2.n1851 0.00266468
R9048 vss_1v2.n1919 vss_1v2.n1860 0.00266468
R9049 vss_1v2.n1920 vss_1v2.n1850 0.00266468
R9050 vss_1v2.n3835 vss_1v2.n3834 0.00260583
R9051 vss_1v2.n1915 vss_1v2.n1850 0.00255075
R9052 vss_1v2.n1923 vss_1v2.n1861 0.00255075
R9053 vss_1v2.n1924 vss_1v2.n1849 0.00255075
R9054 vss_1v2.n1925 vss_1v2.n1862 0.00255075
R9055 vss_1v2.n1926 vss_1v2.n1848 0.00255075
R9056 vss_1v2.n1927 vss_1v2.n1863 0.00255075
R9057 vss_1v2.n2944 vss_1v2.n2443 0.00252144
R9058 vss_1v2.n33 vss_1v2.n388 0.0028689
R9059 vss_1v2.n2861 vss_1v2.n933 0.00243846
R9060 vss_1v2.n1951 vss_1v2.n364 0.0040759
R9061 vss_1v2.n1951 vss_1v2.n1875 0.00243682
R9062 vss_1v2.n1912 vss_1v2.n1875 0.00243682
R9063 vss_1v2.n1912 vss_1v2.n1841 0.00243682
R9064 vss_1v2.n1911 vss_1v2.n1841 0.00243682
R9065 vss_1v2.n1911 vss_1v2.n1876 0.00243682
R9066 vss_1v2.n46 vss_1v2.n1876 0.00243682
R9067 vss_1v2.n4123 vss_1v2.n1878 0.00243177
R9068 vss_1v2.n3486 vss_1v2.n2912 0.00240914
R9069 vss_1v2.n2873 vss_1v2.n2872 0.00240914
R9070 vss_1v2.n2117 vss_1v2.n1974 0.00240914
R9071 vss_1v2.n1602 vss_1v2.n1412 0.00239153
R9072 vss_1v2.n1580 vss_1v2.n1422 0.00239153
R9073 vss_1v2.n1562 vss_1v2.n1428 0.00239153
R9074 vss_1v2.n1767 vss_1v2.n1438 0.00239153
R9075 vss_1v2.n1809 vss_1v2.n1448 0.00239153
R9076 vss_1v2.n3641 vss_1v2.n3640 0.00239153
R9077 vss_1v2.n3642 vss_1v2.n3641 0.00239153
R9078 vss_1v2.n2643 vss_1v2.n2642 0.00239153
R9079 vss_1v2.n2638 vss_1v2.n2632 0.00239153
R9080 vss_1v2.n3653 vss_1v2.n3652 0.00239153
R9081 vss_1v2.n3656 vss_1v2.n3655 0.00239153
R9082 vss_1v2.n3658 vss_1v2.n3657 0.00239153
R9083 vss_1v2.n2631 vss_1v2.n2630 0.00239153
R9084 vss_1v2.n2628 vss_1v2.n432 0.00689097
R9085 vss_1v2.n3667 vss_1v2.n430 0.00783431
R9086 vss_1v2.n3670 vss_1v2.n3669 0.00239153
R9087 vss_1v2.n3671 vss_1v2.n2622 0.00239153
R9088 vss_1v2.n2621 vss_1v2.n2620 0.00239153
R9089 vss_1v2.n2618 vss_1v2.n2612 0.00239153
R9090 vss_1v2.n421 vss_1v2.n420 0.00689097
R9091 vss_1v2.n3680 vss_1v2.n419 0.00783431
R9092 vss_1v2.n2611 vss_1v2.n2610 0.00239153
R9093 vss_1v2.n2606 vss_1v2.n2601 0.00239153
R9094 vss_1v2.n3691 vss_1v2.n3690 0.00239153
R9095 vss_1v2.n3694 vss_1v2.n3693 0.00239153
R9096 vss_1v2.n3696 vss_1v2.n3695 0.00239153
R9097 vss_1v2.n2600 vss_1v2.n2599 0.00239153
R9098 vss_1v2.n2597 vss_1v2.n2596 0.00239153
R9099 vss_1v2.n3708 vss_1v2.n3707 0.00239153
R9100 vss_1v2.n3711 vss_1v2.n3710 0.00239153
R9101 vss_1v2.n2589 vss_1v2.n2588 0.00239153
R9102 vss_1v2.n2587 vss_1v2.n2586 0.00239153
R9103 vss_1v2.n2584 vss_1v2.n2578 0.00239153
R9104 vss_1v2.n428 vss_1v2.n427 0.00689097
R9105 vss_1v2.n3721 vss_1v2.n426 0.00783431
R9106 vss_1v2.n377 vss_1v2.n376 0.00768734
R9107 vss_1v2.n440 vss_1v2.n377 0.00695148
R9108 vss_1v2.n439 vss_1v2.n373 0.00683923
R9109 vss_1v2.n2577 vss_1v2.n2576 0.00239153
R9110 vss_1v2.n2575 vss_1v2.n2574 0.00239153
R9111 vss_1v2.n3110 vss_1v2.n1868 0.00237986
R9112 vss_1v2.n4118 vss_1v2.n46 0.00237986
R9113 vss_1v2.n3011 vss_1v2.n2994 0.00235497
R9114 vss_1v2.n3058 vss_1v2.n31 0.00138254
R9115 vss_1v2.n76 vss_1v2.n3065 0.862421
R9116 vss_1v2.n4104 vss_1v2.n4103 0.00233333
R9117 vss_1v2.n4101 vss_1v2.n1858 0.00232289
R9118 vss_1v2.n1915 vss_1v2.n1861 0.00232289
R9119 vss_1v2.n1924 vss_1v2.n1862 0.00232289
R9120 vss_1v2.n1925 vss_1v2.n1848 0.00232289
R9121 vss_1v2.n1926 vss_1v2.n1863 0.00232289
R9122 vss_1v2.n1927 vss_1v2.n388 0.00381961
R9123 vss_1v2.n2662 vss_1v2.n2661 0.00231818
R9124 vss_1v2.n3335 vss_1v2.n3334 0.00231818
R9125 vss_1v2.n3338 vss_1v2.n3219 0.00231818
R9126 vss_1v2.n3342 vss_1v2.n3340 0.00231818
R9127 vss_1v2.n3158 vss_1v2.n3156 0.00231818
R9128 vss_1v2.n3153 vss_1v2.n2986 0.00231818
R9129 vss_1v2.n3497 vss_1v2.n2886 0.00231818
R9130 vss_1v2.n3502 vss_1v2.n3500 0.00231818
R9131 vss_1v2.n3575 vss_1v2.n3574 0.00231818
R9132 vss_1v2.n3582 vss_1v2.n3581 0.00231818
R9133 vss_1v2.n4031 vss_1v2.n1969 0.00231818
R9134 vss_1v2.n3494 vss_1v2.n485 0.00231818
R9135 vss_1v2.n3488 vss_1v2.n2902 0.00224825
R9136 vss_1v2.n485 vss_1v2.n483 0.00224825
R9137 vss_1v2.n1627 vss_1v2.n685 0.00224603
R9138 vss_1v2.n1637 vss_1v2.n679 0.00224603
R9139 vss_1v2.n1596 vss_1v2.n663 0.00224603
R9140 vss_1v2.n1590 vss_1v2.n657 0.00224603
R9141 vss_1v2.n1574 vss_1v2.n641 0.00224603
R9142 vss_1v2.n1568 vss_1v2.n636 0.00224603
R9143 vss_1v2.n1748 vss_1v2.n620 0.00224603
R9144 vss_1v2.n1758 vss_1v2.n614 0.00224603
R9145 vss_1v2.n1789 vss_1v2.n598 0.00224603
R9146 vss_1v2.n1799 vss_1v2.n592 0.00224603
R9147 vss_1v2.n1455 vss_1v2.n576 0.00224603
R9148 vss_1v2.n1001 vss_1v2.n1000 0.00224603
R9149 vss_1v2.n1018 vss_1v2.n556 0.00224603
R9150 vss_1v2.n998 vss_1v2.n874 0.00224603
R9151 vss_1v2.n1019 vss_1v2.n554 0.00224603
R9152 vss_1v2.n997 vss_1v2.n876 0.00224603
R9153 vss_1v2.n1126 vss_1v2.n552 0.00224603
R9154 vss_1v2.n1020 vss_1v2.n552 0.00224603
R9155 vss_1v2.n996 vss_1v2.n878 0.00224603
R9156 vss_1v2.n1021 vss_1v2.n550 0.00224603
R9157 vss_1v2.n995 vss_1v2.n880 0.00224603
R9158 vss_1v2.n994 vss_1v2.n882 0.00224603
R9159 vss_1v2.n1023 vss_1v2.n546 0.00224603
R9160 vss_1v2.n993 vss_1v2.n884 0.00224603
R9161 vss_1v2.n1024 vss_1v2.n544 0.00224603
R9162 vss_1v2.n992 vss_1v2.n886 0.00224603
R9163 vss_1v2.n1025 vss_1v2.n542 0.00224603
R9164 vss_1v2.n1026 vss_1v2.n540 0.00224603
R9165 vss_1v2.n990 vss_1v2.n890 0.00224603
R9166 vss_1v2.n1027 vss_1v2.n538 0.00224603
R9167 vss_1v2.n989 vss_1v2.n892 0.00224603
R9168 vss_1v2.n1099 vss_1v2.n989 0.00224603
R9169 vss_1v2.n1028 vss_1v2.n536 0.00224603
R9170 vss_1v2.n988 vss_1v2.n894 0.00224603
R9171 vss_1v2.n1029 vss_1v2.n534 0.00224603
R9172 vss_1v2.n1167 vss_1v2.n528 0.00224603
R9173 vss_1v2.n1086 vss_1v2.n1035 0.00224603
R9174 vss_1v2.n1061 vss_1v2.n504 0.00224603
R9175 vss_1v2.n1214 vss_1v2.n1213 0.00224603
R9176 vss_1v2.n420 vss_1v2.n3679 0.00224603
R9177 vss_1v2.n3734 vss_1v2.n3733 0.00224603
R9178 vss_1v2.n1858 vss_1v2.n1857 0.00220896
R9179 vss_1v2.n1914 vss_1v2.n1852 0.00220896
R9180 vss_1v2.n1913 vss_1v2.n1859 0.00220896
R9181 vss_1v2.n1919 vss_1v2.n1851 0.00220896
R9182 vss_1v2.n3838 vss_1v2.n2511 0.00220432
R9183 vss_1v2.n3348 vss_1v2.n3347 0.00218453
R9184 vss_1v2.n2847 vss_1v2.n2846 0.002125
R9185 vss_1v2.n3492 vss_1v2.n2808 0.002125
R9186 vss_1v2.n1627 vss_1v2.n1404 0.00210053
R9187 vss_1v2.n1596 vss_1v2.n1414 0.00210053
R9188 vss_1v2.n1574 vss_1v2.n1424 0.00210053
R9189 vss_1v2.n1556 vss_1v2.n1430 0.00210053
R9190 vss_1v2.n1777 vss_1v2.n1440 0.00210053
R9191 vss_1v2.n1819 vss_1v2.n1450 0.00210053
R9192 vss_1v2.n3659 vss_1v2.n3658 0.00210053
R9193 vss_1v2.n2586 vss_1v2.n2585 0.00210053
R9194 vss_1v2.n3738 vss_1v2.n3737 0.00210053
R9195 vss_1v2.n1934 vss_1v2.n1846 0.00209503
R9196 vss_1v2.n3474 vss_1v2.n3473 0.00207223
R9197 vss_1v2.n3477 vss_1v2.n3476 0.00207223
R9198 vss_1v2.n3479 vss_1v2.n2946 0.00207223
R9199 vss_1v2.n2945 vss_1v2.n2944 0.00207223
R9200 vss_1v2.n4129 vss_1v2.n1891 0.00206097
R9201 vss_1v2.n4129 vss_1v2.n1909 0.00206097
R9202 vss_1v2.n4129 vss_1v2.n1907 0.00206076
R9203 vss_1v2.n3067 vss_1v2.n2878 0.00203846
R9204 vss_1v2.n4095 vss_1v2.n43 0.00198398
R9205 vss_1v2.n3208 vss_1v2.n15 0.00198398
R9206 vss_1v2.n33 vss_1v2.n488 0.00737884
R9207 vss_1v2.n1947 vss_1v2.n1843 0.0019811
R9208 vss_1v2.n3329 vss_1v2.n3328 0.00196853
R9209 vss_1v2.n3333 vss_1v2.n3331 0.00196853
R9210 vss_1v2.n3344 vss_1v2.n3343 0.00196853
R9211 vss_1v2.n3163 vss_1v2.n3160 0.00196853
R9212 vss_1v2.t20 vss_1v2.n2883 0.00196853
R9213 vss_1v2.n3572 vss_1v2.n2690 0.00196853
R9214 vss_1v2.n3382 vss_1v2.n3347 0.00195993
R9215 vss_1v2.n3391 vss_1v2.n2977 0.00195993
R9216 vss_1v2.n2973 vss_1v2.n2972 0.00195993
R9217 vss_1v2.n2973 vss_1v2.n2965 0.00195993
R9218 vss_1v2.n3402 vss_1v2.n3399 0.00195993
R9219 vss_1v2.n3448 vss_1v2.n3440 0.00195993
R9220 vss_1v2.n3479 vss_1v2.n3478 0.00195993
R9221 vss_1v2.n1631 vss_1v2.n1630 0.00192342
R9222 vss_1v2.n1632 vss_1v2.n1631 0.00192342
R9223 vss_1v2.n1632 vss_1v2.n1617 0.00192342
R9224 vss_1v2.n1640 vss_1v2.n1617 0.00192342
R9225 vss_1v2.n1641 vss_1v2.n1640 0.00192342
R9226 vss_1v2.n1642 vss_1v2.n1641 0.00192342
R9227 vss_1v2.n1642 vss_1v2.n1611 0.00192342
R9228 vss_1v2.n1650 vss_1v2.n1611 0.00192342
R9229 vss_1v2.n1651 vss_1v2.n1650 0.00192342
R9230 vss_1v2.n1652 vss_1v2.n1651 0.00192342
R9231 vss_1v2.n1652 vss_1v2.n1606 0.00192342
R9232 vss_1v2.n1660 vss_1v2.n1606 0.00192342
R9233 vss_1v2.n1661 vss_1v2.n1660 0.00192342
R9234 vss_1v2.n1662 vss_1v2.n1661 0.00192342
R9235 vss_1v2.n1662 vss_1v2.n1600 0.00192342
R9236 vss_1v2.n1669 vss_1v2.n1600 0.00192342
R9237 vss_1v2.n1670 vss_1v2.n1669 0.00192342
R9238 vss_1v2.n1671 vss_1v2.n1670 0.00192342
R9239 vss_1v2.n1671 vss_1v2.n1594 0.00192342
R9240 vss_1v2.n1678 vss_1v2.n1594 0.00192342
R9241 vss_1v2.n1679 vss_1v2.n1678 0.00192342
R9242 vss_1v2.n1680 vss_1v2.n1679 0.00192342
R9243 vss_1v2.n1680 vss_1v2.n1588 0.00192342
R9244 vss_1v2.n1688 vss_1v2.n1588 0.00192342
R9245 vss_1v2.n1689 vss_1v2.n1688 0.00192342
R9246 vss_1v2.n1690 vss_1v2.n1689 0.00192342
R9247 vss_1v2.n1690 vss_1v2.n1582 0.00192342
R9248 vss_1v2.n1697 vss_1v2.n1582 0.00192342
R9249 vss_1v2.n1698 vss_1v2.n1697 0.00192342
R9250 vss_1v2.n1699 vss_1v2.n1698 0.00192342
R9251 vss_1v2.n1699 vss_1v2.n1576 0.00192342
R9252 vss_1v2.n1706 vss_1v2.n1576 0.00192342
R9253 vss_1v2.n1707 vss_1v2.n1706 0.00192342
R9254 vss_1v2.n1708 vss_1v2.n1707 0.00192342
R9255 vss_1v2.n1708 vss_1v2.n1570 0.00192342
R9256 vss_1v2.n1715 vss_1v2.n1570 0.00192342
R9257 vss_1v2.n1716 vss_1v2.n1715 0.00192342
R9258 vss_1v2.n1717 vss_1v2.n1716 0.00192342
R9259 vss_1v2.n1717 vss_1v2.n1564 0.00192342
R9260 vss_1v2.n1724 vss_1v2.n1564 0.00192342
R9261 vss_1v2.n1725 vss_1v2.n1724 0.00192342
R9262 vss_1v2.n1726 vss_1v2.n1725 0.00192342
R9263 vss_1v2.n1726 vss_1v2.n1558 0.00192342
R9264 vss_1v2.n1733 vss_1v2.n1558 0.00192342
R9265 vss_1v2.n1734 vss_1v2.n1733 0.00192342
R9266 vss_1v2.n1735 vss_1v2.n1734 0.00192342
R9267 vss_1v2.n1735 vss_1v2.n1552 0.00192342
R9268 vss_1v2.n1743 vss_1v2.n1552 0.00192342
R9269 vss_1v2.n1744 vss_1v2.n1743 0.00192342
R9270 vss_1v2.n1745 vss_1v2.n1744 0.00192342
R9271 vss_1v2.n1745 vss_1v2.n1546 0.00192342
R9272 vss_1v2.n1753 vss_1v2.n1546 0.00192342
R9273 vss_1v2.n1754 vss_1v2.n1753 0.00192342
R9274 vss_1v2.n1755 vss_1v2.n1754 0.00192342
R9275 vss_1v2.n1755 vss_1v2.n1541 0.00192342
R9276 vss_1v2.n1762 vss_1v2.n1541 0.00192342
R9277 vss_1v2.n1763 vss_1v2.n1762 0.00192342
R9278 vss_1v2.n1764 vss_1v2.n1763 0.00192342
R9279 vss_1v2.n1764 vss_1v2.n1535 0.00192342
R9280 vss_1v2.n1772 vss_1v2.n1535 0.00192342
R9281 vss_1v2.n1773 vss_1v2.n1772 0.00192342
R9282 vss_1v2.n1774 vss_1v2.n1773 0.00192342
R9283 vss_1v2.n1774 vss_1v2.n1530 0.00192342
R9284 vss_1v2.n1782 vss_1v2.n1530 0.00192342
R9285 vss_1v2.n1783 vss_1v2.n1782 0.00192342
R9286 vss_1v2.n1784 vss_1v2.n1783 0.00192342
R9287 vss_1v2.n1784 vss_1v2.n1524 0.00192342
R9288 vss_1v2.n1792 vss_1v2.n1524 0.00192342
R9289 vss_1v2.n1793 vss_1v2.n1792 0.00192342
R9290 vss_1v2.n1794 vss_1v2.n1793 0.00192342
R9291 vss_1v2.n1794 vss_1v2.n1519 0.00192342
R9292 vss_1v2.n1802 vss_1v2.n1519 0.00192342
R9293 vss_1v2.n1803 vss_1v2.n1802 0.00192342
R9294 vss_1v2.n1804 vss_1v2.n1803 0.00192342
R9295 vss_1v2.n1804 vss_1v2.n1514 0.00192342
R9296 vss_1v2.n1812 vss_1v2.n1514 0.00192342
R9297 vss_1v2.n1813 vss_1v2.n1812 0.00192342
R9298 vss_1v2.n1814 vss_1v2.n1813 0.00192342
R9299 vss_1v2.n1814 vss_1v2.n1509 0.00192342
R9300 vss_1v2.n1822 vss_1v2.n1509 0.00192342
R9301 vss_1v2.n1823 vss_1v2.n1822 0.00192342
R9302 vss_1v2.n1824 vss_1v2.n1823 0.00192342
R9303 vss_1v2.n1824 vss_1v2.n1503 0.00192342
R9304 vss_1v2.n1832 vss_1v2.n1503 0.00192342
R9305 vss_1v2.n1833 vss_1v2.n1832 0.00192342
R9306 vss_1v2.n1834 vss_1v2.n1833 0.00192342
R9307 vss_1v2.n1834 vss_1v2.n1502 0.00192342
R9308 vss_1v2.n1502 vss_1v2.n1501 0.00192342
R9309 vss_1v2.n1501 vss_1v2.n1459 0.00192342
R9310 vss_1v2.n1494 vss_1v2.n1459 0.00192342
R9311 vss_1v2.n1494 vss_1v2.n1493 0.00192342
R9312 vss_1v2.n1493 vss_1v2.n1492 0.00192342
R9313 vss_1v2.n1492 vss_1v2.n1465 0.00192342
R9314 vss_1v2.n1484 vss_1v2.n1465 0.00192342
R9315 vss_1v2.n1484 vss_1v2.n1483 0.00192342
R9316 vss_1v2.n1483 vss_1v2.n1482 0.00192342
R9317 vss_1v2.n1482 vss_1v2.n1471 0.00192342
R9318 vss_1v2.n1474 vss_1v2.n1471 0.00192342
R9319 vss_1v2.n1474 vss_1v2.n489 0.00192342
R9320 vss_1v2.n486 vss_1v2.n489 0.00192342
R9321 vss_1v2.n1121 vss_1v2.n487 0.00192342
R9322 vss_1v2.n1122 vss_1v2.n1121 0.00192342
R9323 vss_1v2.n1123 vss_1v2.n1122 0.00192342
R9324 vss_1v2.n1123 vss_1v2.n1113 0.00192342
R9325 vss_1v2.n1131 vss_1v2.n1113 0.00192342
R9326 vss_1v2.n1132 vss_1v2.n1131 0.00192342
R9327 vss_1v2.n1133 vss_1v2.n1132 0.00192342
R9328 vss_1v2.n1133 vss_1v2.n1107 0.00192342
R9329 vss_1v2.n1141 vss_1v2.n1107 0.00192342
R9330 vss_1v2.n1142 vss_1v2.n1141 0.00192342
R9331 vss_1v2.n1143 vss_1v2.n1142 0.00192342
R9332 vss_1v2.n1143 vss_1v2.n1101 0.00192342
R9333 vss_1v2.n1151 vss_1v2.n1101 0.00192342
R9334 vss_1v2.n1152 vss_1v2.n1151 0.00192342
R9335 vss_1v2.n1153 vss_1v2.n1152 0.00192342
R9336 vss_1v2.n1153 vss_1v2.n1095 0.00192342
R9337 vss_1v2.n1160 vss_1v2.n1095 0.00192342
R9338 vss_1v2.n1161 vss_1v2.n1160 0.00192342
R9339 vss_1v2.n1162 vss_1v2.n1161 0.00192342
R9340 vss_1v2.n1162 vss_1v2.n1090 0.00192342
R9341 vss_1v2.n1170 vss_1v2.n1090 0.00192342
R9342 vss_1v2.n1171 vss_1v2.n1170 0.00192342
R9343 vss_1v2.n1172 vss_1v2.n1171 0.00192342
R9344 vss_1v2.n1172 vss_1v2.n1084 0.00192342
R9345 vss_1v2.n1179 vss_1v2.n1084 0.00192342
R9346 vss_1v2.n1180 vss_1v2.n1179 0.00192342
R9347 vss_1v2.n1181 vss_1v2.n1180 0.00192342
R9348 vss_1v2.n1181 vss_1v2.n1078 0.00192342
R9349 vss_1v2.n1189 vss_1v2.n1078 0.00192342
R9350 vss_1v2.n1190 vss_1v2.n1189 0.00192342
R9351 vss_1v2.n1191 vss_1v2.n1190 0.00192342
R9352 vss_1v2.n1191 vss_1v2.n1072 0.00192342
R9353 vss_1v2.n1199 vss_1v2.n1072 0.00192342
R9354 vss_1v2.n1200 vss_1v2.n1199 0.00192342
R9355 vss_1v2.n1201 vss_1v2.n1200 0.00192342
R9356 vss_1v2.n1201 vss_1v2.n1066 0.00192342
R9357 vss_1v2.n1208 vss_1v2.n1066 0.00192342
R9358 vss_1v2.n1209 vss_1v2.n1208 0.00192342
R9359 vss_1v2.n1210 vss_1v2.n1209 0.00192342
R9360 vss_1v2.n1210 vss_1v2.n1065 0.00192342
R9361 vss_1v2.n1065 vss_1v2.n946 0.00192342
R9362 vss_1v2.n4140 vss_1v2.n946 0.00192342
R9363 vss_1v2.n4141 vss_1v2.n4140 0.00192342
R9364 vss_1v2.n4142 vss_1v2.n4141 0.00192342
R9365 vss_1v2.n4142 vss_1v2.n945 0.00192342
R9366 vss_1v2.n3608 vss_1v2.n945 0.00192342
R9367 vss_1v2.n3609 vss_1v2.n3608 0.00192342
R9368 vss_1v2.n3609 vss_1v2.n3605 0.00192342
R9369 vss_1v2.n3615 vss_1v2.n3605 0.00192342
R9370 vss_1v2.n3616 vss_1v2.n3615 0.00192342
R9371 vss_1v2.n3617 vss_1v2.n3616 0.00192342
R9372 vss_1v2.n3617 vss_1v2.n3601 0.00192342
R9373 vss_1v2.n3623 vss_1v2.n3601 0.00192342
R9374 vss_1v2.n3624 vss_1v2.n3623 0.00192342
R9375 vss_1v2.n3625 vss_1v2.n3624 0.00192342
R9376 vss_1v2.n3625 vss_1v2.n3600 0.00192342
R9377 vss_1v2.n3600 vss_1v2.n2655 0.00192342
R9378 vss_1v2.n3633 vss_1v2.n2655 0.00192342
R9379 vss_1v2.n3634 vss_1v2.n3633 0.00192342
R9380 vss_1v2.n3635 vss_1v2.n3634 0.00192342
R9381 vss_1v2.n3635 vss_1v2.n2635 0.00192342
R9382 vss_1v2.n3646 vss_1v2.n2635 0.00192342
R9383 vss_1v2.n3647 vss_1v2.n3646 0.00192342
R9384 vss_1v2.n3648 vss_1v2.n3647 0.00192342
R9385 vss_1v2.n3648 vss_1v2.n2625 0.00192342
R9386 vss_1v2.n3662 vss_1v2.n2625 0.00192342
R9387 vss_1v2.n3663 vss_1v2.n3662 0.00192342
R9388 vss_1v2.n3664 vss_1v2.n3663 0.00192342
R9389 vss_1v2.n3664 vss_1v2.n2615 0.00192342
R9390 vss_1v2.n3674 vss_1v2.n2615 0.00192342
R9391 vss_1v2.n3675 vss_1v2.n3674 0.00192342
R9392 vss_1v2.n3676 vss_1v2.n3675 0.00192342
R9393 vss_1v2.n3676 vss_1v2.n2604 0.00192342
R9394 vss_1v2.n3684 vss_1v2.n2604 0.00192342
R9395 vss_1v2.n3685 vss_1v2.n3684 0.00192342
R9396 vss_1v2.n3686 vss_1v2.n3685 0.00192342
R9397 vss_1v2.n3686 vss_1v2.n2593 0.00192342
R9398 vss_1v2.n3700 vss_1v2.n2593 0.00192342
R9399 vss_1v2.n3701 vss_1v2.n3700 0.00192342
R9400 vss_1v2.n3702 vss_1v2.n3701 0.00192342
R9401 vss_1v2.n3702 vss_1v2.n2581 0.00192342
R9402 vss_1v2.n3715 vss_1v2.n2581 0.00192342
R9403 vss_1v2.n3716 vss_1v2.n3715 0.00192342
R9404 vss_1v2.n3717 vss_1v2.n3716 0.00192342
R9405 vss_1v2.n3717 vss_1v2.n2572 0.00192342
R9406 vss_1v2.n3725 vss_1v2.n2572 0.00192342
R9407 vss_1v2.n3726 vss_1v2.n3725 0.00192342
R9408 vss_1v2.n3727 vss_1v2.n3726 0.00192342
R9409 vss_1v2.n3727 vss_1v2.n2562 0.00192342
R9410 vss_1v2.n3741 vss_1v2.n2562 0.00192342
R9411 vss_1v2.n3742 vss_1v2.n3741 0.00192342
R9412 vss_1v2.n3743 vss_1v2.n3742 0.00192342
R9413 vss_1v2.n3743 vss_1v2.n2551 0.00192342
R9414 vss_1v2.n3753 vss_1v2.n2551 0.00192342
R9415 vss_1v2.n3754 vss_1v2.n3753 0.00192342
R9416 vss_1v2.n3755 vss_1v2.n3754 0.00192342
R9417 vss_1v2.n3755 vss_1v2.n2540 0.00192342
R9418 vss_1v2.n3763 vss_1v2.n2540 0.00192342
R9419 vss_1v2.n3764 vss_1v2.n3763 0.00192342
R9420 vss_1v2.n3765 vss_1v2.n3764 0.00192342
R9421 vss_1v2.n3765 vss_1v2.n2530 0.00192342
R9422 vss_1v2.n3779 vss_1v2.n2530 0.00192342
R9423 vss_1v2.n487 vss_1v2.n486 0.00192342
R9424 vss_1v2.n4024 vss_1v2.n4023 0.0018986
R9425 vss_1v2.n2847 vss_1v2.n1965 0.00187493
R9426 vss_1v2.n3496 vss_1v2.n2808 0.00187493
R9427 vss_1v2.n0 vss_1v2.n39 0.00252106
R9428 vss_1v2.n2912 vss_1v2.n2911 0.00184763
R9429 vss_1v2.n3444 vss_1v2.n3443 0.00184763
R9430 vss_1v2.n3447 vss_1v2.n3446 0.00184763
R9431 vss_1v2.n3440 vss_1v2.n3438 0.00184763
R9432 vss_1v2.n3437 vss_1v2.n3435 0.00184763
R9433 vss_1v2.n2118 vss_1v2.n1970 0.00184763
R9434 vss_1v2.n1647 vss_1v2.n1383 0.00180952
R9435 vss_1v2.n1584 vss_1v2.n1373 0.00180952
R9436 vss_1v2.n1544 vss_1v2.n1357 0.00180952
R9437 vss_1v2.n1797 vss_1v2.n1347 0.00180952
R9438 vss_1v2.n2608 vss_1v2.n2607 0.00180952
R9439 vss_1v2.n4022 vss_1v2.n81 0.001338
R9440 vss_1v2.n4019 vss_1v2.n1999 0.00179459
R9441 vss_1v2.n4129 vss_1v2.n1906 0.00177746
R9442 vss_1v2.n352 vss_1v2.n3489 0.00175874
R9443 vss_1v2.n1941 vss_1v2.n361 0.00373395
R9444 vss_1v2.n1948 vss_1v2.n1872 0.00175324
R9445 vss_1v2.n1942 vss_1v2.n1843 0.00175324
R9446 vss_1v2.n1949 vss_1v2.n1873 0.00175324
R9447 vss_1v2.n1950 vss_1v2.n1842 0.00175324
R9448 vss_1v2.n1874 vss_1v2.n211 0.00175324
R9449 vss_1v2.n3402 vss_1v2.n3400 0.00173532
R9450 vss_1v2.n3190 vss_1v2.n3189 0.00166667
R9451 vss_1v2.n1288 vss_1v2.n1287 0.00166667
R9452 vss_1v2.n3182 vss_1v2.n3181 0.00166667
R9453 vss_1v2.n3167 vss_1v2.n1286 0.00166667
R9454 vss_1v2.n3171 vss_1v2.n2982 0.00166667
R9455 vss_1v2.n3239 vss_1v2.n2831 0.00166667
R9456 vss_1v2.n3235 vss_1v2.n3234 0.00166667
R9457 vss_1v2.n3134 vss_1v2.n2835 0.00166667
R9458 vss_1v2.n3140 vss_1v2.n3139 0.00166667
R9459 vss_1v2.n3000 vss_1v2.n1291 0.00166667
R9460 vss_1v2.n3009 vss_1v2.n3008 0.00166667
R9461 vss_1v2.n2993 vss_1v2.n1284 0.00166667
R9462 vss_1v2.n2890 vss_1v2.n2826 0.00166667
R9463 vss_1v2.n3092 vss_1v2.n3091 0.00166667
R9464 vss_1v2.n3579 vss_1v2.n2684 0.00166667
R9465 vss_1v2.n2824 vss_1v2.n2822 0.00166667
R9466 vss_1v2.n2839 vss_1v2.n2838 0.00166667
R9467 vss_1v2.n2839 vss_1v2.n2825 0.00166667
R9468 vss_1v2.n2850 vss_1v2.n2849 0.00166667
R9469 vss_1v2.n4030 vss_1v2.n1973 0.00166667
R9470 vss_1v2.n3467 vss_1v2.n2942 0.00166667
R9471 vss_1v2.n3467 vss_1v2.n3456 0.00166667
R9472 vss_1v2.n3475 vss_1v2.n2931 0.00166667
R9473 vss_1v2.n3573 vss_1v2.n2680 0.00166667
R9474 vss_1v2.n3584 vss_1v2.n2678 0.00166667
R9475 vss_1v2.n3567 vss_1v2.n2678 0.00166667
R9476 vss_1v2.n3562 vss_1v2.n2666 0.00166667
R9477 vss_1v2.n3427 vss_1v2.n2903 0.00166667
R9478 vss_1v2.n3427 vss_1v2.n2952 0.00166667
R9479 vss_1v2.n3394 vss_1v2.n2941 0.00166667
R9480 vss_1v2.n3434 vss_1v2.n3394 0.00166667
R9481 vss_1v2.n3395 vss_1v2.n2934 0.00166667
R9482 vss_1v2.n3395 vss_1v2.n2875 0.00166667
R9483 vss_1v2.n452 vss_1v2.n2874 0.00166667
R9484 vss_1v2.n3454 vss_1v2.n452 0.00166667
R9485 vss_1v2.n3442 vss_1v2.n2933 0.00166667
R9486 vss_1v2.n3157 vss_1v2.n2695 0.00166667
R9487 vss_1v2.n3151 vss_1v2.n2676 0.00166667
R9488 vss_1v2.n3151 vss_1v2.n2806 0.00166667
R9489 vss_1v2.n3146 vss_1v2.n2671 0.00166667
R9490 vss_1v2.n2867 vss_1v2.n2677 0.00166667
R9491 vss_1v2.n3498 vss_1v2.n2670 0.00166667
R9492 vss_1v2.n3373 vss_1v2.n2955 0.00166667
R9493 vss_1v2.n3377 vss_1v2.n2938 0.00166667
R9494 vss_1v2.n3377 vss_1v2.n2958 0.00166667
R9495 vss_1v2.n3384 vss_1v2.n2936 0.00166667
R9496 vss_1v2.n3384 vss_1v2.n2954 0.00166667
R9497 vss_1v2.n2959 vss_1v2.n2939 0.00166667
R9498 vss_1v2.n3393 vss_1v2.n2959 0.00166667
R9499 vss_1v2.n2967 vss_1v2.n2935 0.00166667
R9500 vss_1v2.n2967 vss_1v2.n2953 0.00166667
R9501 vss_1v2.n2962 vss_1v2.n2940 0.00166667
R9502 vss_1v2.n2962 vss_1v2.n2905 0.00166667
R9503 vss_1v2.n2805 vss_1v2.n457 0.00166667
R9504 vss_1v2.n3587 vss_1v2.n3586 0.00166667
R9505 vss_1v2.n2853 vss_1v2.n2852 0.00166667
R9506 vss_1v2.n2859 vss_1v2.n2854 0.00166667
R9507 vss_1v2.n3537 vss_1v2.n3536 0.00166667
R9508 vss_1v2.n3532 vss_1v2.n3531 0.00166667
R9509 vss_1v2.n3822 vss_1v2.n2499 0.00166667
R9510 vss_1v2.n2517 vss_1v2.n2460 0.00166667
R9511 vss_1v2.n305 vss_1v2.n304 0.00166667
R9512 vss_1v2.n307 vss_1v2.n306 0.00166667
R9513 vss_1v2.n1608 vss_1v2.n757 0.00166402
R9514 vss_1v2.n1657 vss_1v2.n760 0.00166402
R9515 vss_1v2.n1586 vss_1v2.n779 0.00166402
R9516 vss_1v2.n1578 vss_1v2.n782 0.00166402
R9517 vss_1v2.n1729 vss_1v2.n800 0.00166402
R9518 vss_1v2.n1556 vss_1v2.n803 0.00166402
R9519 vss_1v2.n1769 vss_1v2.n822 0.00166402
R9520 vss_1v2.n1777 vss_1v2.n825 0.00166402
R9521 vss_1v2.n1511 vss_1v2.n844 0.00166402
R9522 vss_1v2.n1819 vss_1v2.n847 0.00166402
R9523 vss_1v2.n1461 vss_1v2.n1011 0.00166402
R9524 vss_1v2.n1469 vss_1v2.n1013 0.00166402
R9525 vss_1v2.n1469 vss_1v2.n863 0.00166402
R9526 vss_1v2.n1477 vss_1v2.n867 0.00166402
R9527 vss_1v2.n1111 vss_1v2.n1022 0.00166402
R9528 vss_1v2.n1138 vss_1v2.n884 0.00166402
R9529 vss_1v2.n1103 vss_1v2.n1024 0.00166402
R9530 vss_1v2.n1146 vss_1v2.n888 0.00166402
R9531 vss_1v2.n1080 vss_1v2.n908 0.00166402
R9532 vss_1v2.n1068 vss_1v2.n965 0.00166402
R9533 vss_1v2.n952 vss_1v2.n932 0.00166402
R9534 vss_1v2.n2641 vss_1v2.n2640 0.00166402
R9535 vss_1v2.n3693 vss_1v2.n3692 0.00166402
R9536 vss_1v2.n3705 vss_1v2.n2590 0.00166402
R9537 vss_1v2.n3750 vss_1v2.n2559 0.00166402
R9538 vss_1v2.n42 vss_1v2.n71 0.00317301
R9539 vss_1v2.n1921 vss_1v2.n1920 0.00163931
R9540 vss_1v2.n1923 vss_1v2.n1922 0.00163931
R9541 vss_1v2.n32 vss_1v2.n1864 0.00282836
R9542 vss_1v2.n2999 vss_1v2.n1847 0.00163931
R9543 vss_1v2.n1928 vss_1v2.n1865 0.00163931
R9544 vss_1v2.n1929 vss_1v2.n1846 0.00163931
R9545 vss_1v2.n1934 vss_1v2.n1933 0.00163931
R9546 vss_1v2.n1933 vss_1v2.n1866 0.00163931
R9547 vss_1v2.n1940 vss_1v2.n1939 0.00163931
R9548 vss_1v2.n1948 vss_1v2.n1947 0.00163931
R9549 vss_1v2.n3431 vss_1v2.n3430 0.00162302
R9550 vss_1v2.n3432 vss_1v2.n3400 0.00162302
R9551 vss_1v2.n3399 vss_1v2.n3398 0.00162302
R9552 vss_1v2.n3396 vss_1v2.t349 0.00162302
R9553 vss_1v2.n2877 vss_1v2.n2876 0.00162302
R9554 vss_1v2.n2872 vss_1v2.n2871 0.00162302
R9555 vss_1v2.n3489 vss_1v2.n3488 0.00161888
R9556 vss_1v2.n3495 vss_1v2.n3494 0.00161888
R9557 vss_1v2.n1613 vss_1v2.n1385 0.00151852
R9558 vss_1v2.n1592 vss_1v2.n1375 0.00151852
R9559 vss_1v2.n1748 vss_1v2.n1359 0.00151852
R9560 vss_1v2.n1789 vss_1v2.n1349 0.00151852
R9561 vss_1v2.n1455 vss_1v2.n1339 0.00151852
R9562 vss_1v2.n3697 vss_1v2.n3696 0.00151852
R9563 vss_1v2.n3776 vss_1v2.n3775 0.00151852
R9564 vss_1v2.n3448 vss_1v2.n3447 0.00151072
R9565 vss_1v2.n2120 vss_1v2.n2119 0.00151072
R9566 vss_1v2.n3461 vss_1v2.n1974 0.00151072
R9567 vss_1v2.n2880 vss_1v2.n2879 0.00147902
R9568 vss_1v2.n4032 vss_1v2.n4031 0.00147902
R9569 vss_1v2.n3056 vss_1v2.n1870 0.00141145
R9570 vss_1v2.n3055 vss_1v2.n1844 0.00141145
R9571 vss_1v2.n1946 vss_1v2.n1871 0.00141145
R9572 vss_1v2.n2969 vss_1v2.n2968 0.00139842
R9573 vss_1v2.n2972 vss_1v2.n2971 0.00139842
R9574 vss_1v2.n2965 vss_1v2.n2964 0.00139842
R9575 vss_1v2.n2963 vss_1v2.n2961 0.00139842
R9576 vss_1v2.n2908 vss_1v2.n2904 0.00139842
R9577 vss_1v2.n2120 vss_1v2.n2117 0.00139842
R9578 vss_1v2.n3191 vss_1v2.n1288 0.00133332
R9579 vss_1v2.n3191 vss_1v2.n3190 0.00133332
R9580 vss_1v2.n3209 vss_1v2.n1291 0.00133332
R9581 vss_1v2.n3180 vss_1v2.n1286 0.00133332
R9582 vss_1v2.n3181 vss_1v2.n3180 0.00133332
R9583 vss_1v2.n3236 vss_1v2.n3235 0.00133332
R9584 vss_1v2.n3236 vss_1v2.n2831 0.00133332
R9585 vss_1v2.n3139 vss_1v2.n3138 0.00133332
R9586 vss_1v2.n3138 vss_1v2.n2835 0.00133332
R9587 vss_1v2.n3010 vss_1v2.n1284 0.00133332
R9588 vss_1v2.n3010 vss_1v2.n3009 0.00133332
R9589 vss_1v2.n3209 vss_1v2.n2982 0.00133332
R9590 vss_1v2.n3091 vss_1v2.n3090 0.00133332
R9591 vss_1v2.n3090 vss_1v2.n2826 0.00133332
R9592 vss_1v2.n2822 vss_1v2.n2821 0.00133332
R9593 vss_1v2.n2821 vss_1v2.n2684 0.00133332
R9594 vss_1v2.n2846 vss_1v2.n2838 0.00133332
R9595 vss_1v2.n2849 vss_1v2.n2848 0.00133332
R9596 vss_1v2.n2848 vss_1v2.n2825 0.00133332
R9597 vss_1v2.n3535 vss_1v2.n3532 0.00133332
R9598 vss_1v2.n3543 vss_1v2.n2854 0.00133332
R9599 vss_1v2.n3536 vss_1v2.n3535 0.00133332
R9600 vss_1v2.n3543 vss_1v2.n2853 0.00133332
R9601 vss_1v2.n3586 vss_1v2.n2659 0.00133332
R9602 vss_1v2.n2805 vss_1v2.n2659 0.00133332
R9603 vss_1v2.n3337 vss_1v2.n306 0.00133332
R9604 vss_1v2.n3337 vss_1v2.n304 0.00133332
R9605 vss_1v2.n2991 vss_1v2.n2671 0.00133332
R9606 vss_1v2.n2991 vss_1v2.n2806 0.00133332
R9607 vss_1v2.n3154 vss_1v2.n2676 0.00133332
R9608 vss_1v2.n3154 vss_1v2.n2695 0.00133332
R9609 vss_1v2.n3496 vss_1v2.n2670 0.00133332
R9610 vss_1v2.n3492 vss_1v2.n2677 0.00133332
R9611 vss_1v2.n3566 vss_1v2.n2666 0.00133332
R9612 vss_1v2.n3567 vss_1v2.n3566 0.00133332
R9613 vss_1v2.n3584 vss_1v2.n3583 0.00133332
R9614 vss_1v2.n3583 vss_1v2.n2680 0.00133332
R9615 vss_1v2.n2517 vss_1v2.n2500 0.00133332
R9616 vss_1v2.n3822 vss_1v2.n2500 0.00133332
R9617 vss_1v2.n3375 vss_1v2.n2938 0.00133332
R9618 vss_1v2.n3375 vss_1v2.n2955 0.00133332
R9619 vss_1v2.n3381 vss_1v2.n2936 0.00133332
R9620 vss_1v2.n3381 vss_1v2.n2958 0.00133332
R9621 vss_1v2.n2954 vss_1v2.n308 0.00133332
R9622 vss_1v2.n2939 vss_1v2.n308 0.00133332
R9623 vss_1v2.n3392 vss_1v2.n2935 0.00133332
R9624 vss_1v2.n3393 vss_1v2.n3392 0.00133332
R9625 vss_1v2.n2970 vss_1v2.n2940 0.00133332
R9626 vss_1v2.n2970 vss_1v2.n2953 0.00133332
R9627 vss_1v2.n3487 vss_1v2.n2903 0.00133332
R9628 vss_1v2.n3487 vss_1v2.n2905 0.00133332
R9629 vss_1v2.n3428 vss_1v2.n2941 0.00133332
R9630 vss_1v2.n3428 vss_1v2.n2952 0.00133332
R9631 vss_1v2.n3433 vss_1v2.n2934 0.00133332
R9632 vss_1v2.n3434 vss_1v2.n3433 0.00133332
R9633 vss_1v2.n3505 vss_1v2.n2875 0.00133332
R9634 vss_1v2.n3505 vss_1v2.n2874 0.00133332
R9635 vss_1v2.n3453 vss_1v2.n2933 0.00133332
R9636 vss_1v2.n3454 vss_1v2.n3453 0.00133332
R9637 vss_1v2.n3463 vss_1v2.n2942 0.00133332
R9638 vss_1v2.n3463 vss_1v2.n1973 0.00133332
R9639 vss_1v2.n3472 vss_1v2.n2931 0.00133332
R9640 vss_1v2.n3472 vss_1v2.n3456 0.00133332
R9641 vss_1v2.n1932 vss_1v2.n358 0.00333516
R9642 vss_1v2.n1935 vss_1v2.n1867 0.00129751
R9643 vss_1v2.n1936 vss_1v2.n1845 0.00129751
R9644 vss_1v2.n3109 vss_1v2.n1868 0.00129751
R9645 vss_1v2.n3111 vss_1v2.n3110 0.00129751
R9646 vss_1v2.n2871 vss_1v2.n2869 0.00128612
R9647 vss_1v2.n376 vss_1v2.n2873 0.00128612
R9648 vss_1v2.n3470 vss_1v2.n3469 0.00128612
R9649 vss_1v2.n3478 vss_1v2.n3477 0.00128612
R9650 vss_1v2.t58 vss_1v2.n4020 0.00126424
R9651 vss_1v2.t56 vss_1v2.n1999 0.00126149
R9652 vss_1v2.n1635 vss_1v2.n1406 0.00122751
R9653 vss_1v2.n1675 vss_1v2.n1416 0.00122751
R9654 vss_1v2.n1548 vss_1v2.n1432 0.00122751
R9655 vss_1v2.n1528 vss_1v2.n1442 0.00122751
R9656 vss_1v2.n1827 vss_1v2.n1452 0.00122751
R9657 vss_1v2.n2640 vss_1v2.n2639 0.00122751
R9658 vss_1v2.n3706 vss_1v2.n3705 0.00122751
R9659 vss_1v2.n3732 vss_1v2.n3731 0.00122751
R9660 vss_1v2.n3735 vss_1v2.n3734 0.00122751
R9661 vss_1v2.n3737 vss_1v2.n3736 0.00122751
R9662 vss_1v2.n2568 vss_1v2.n2567 0.00122751
R9663 vss_1v2.n2565 vss_1v2.n450 0.00630838
R9664 vss_1v2.n3746 vss_1v2.n448 0.00667029
R9665 vss_1v2.n3749 vss_1v2.n3748 0.00122751
R9666 vss_1v2.n2559 vss_1v2.n2558 0.00122751
R9667 vss_1v2.n2557 vss_1v2.n2556 0.00122751
R9668 vss_1v2.n2554 vss_1v2.n2548 0.00122751
R9669 vss_1v2.n446 vss_1v2.n445 0.00630838
R9670 vss_1v2.n3759 vss_1v2.n444 0.00667029
R9671 vss_1v2.n356 vss_1v2.n51 0.00769482
R9672 vss_1v2.n369 vss_1v2.n3372 0.00638991
R9673 vss_1v2.n464 vss_1v2.n367 0.00609084
R9674 vss_1v2.n366 vss_1v2.n365 0.00596867
R9675 vss_1v2.n363 vss_1v2.n362 0.00528509
R9676 vss_1v2.n360 vss_1v2.n359 0.00517116
R9677 vss_1v2.n371 vss_1v2.n370 0.0039942
R9678 vss_1v2.n4020 vss_1v2.n396 0.00481258
R9679 vss_1v2.n4032 vss_1v2.n408 0.0046958
R9680 vss_1v2.n467 vss_1v2.n424 0.00465518
R9681 vss_1v2.n438 vss_1v2.n473 0.00302096
R9682 vss_1v2.n478 vss_1v2.n439 0.00302096
R9683 vss_1v2.n440 vss_1v2.n455 0.00313321
R9684 vss_1v2.n2547 vss_1v2.n2546 0.00122751
R9685 vss_1v2.n2544 vss_1v2.n2543 0.00122751
R9686 vss_1v2.n2542 vss_1v2.n2537 0.00122751
R9687 vss_1v2.n3770 vss_1v2.n3769 0.00122751
R9688 vss_1v2.n3773 vss_1v2.n3772 0.00122751
R9689 vss_1v2.n3775 vss_1v2.n3774 0.00122751
R9690 vss_1v2.n2536 vss_1v2.n2535 0.00122751
R9691 vss_1v2.n2533 vss_1v2.n2527 0.00122751
R9692 vss_1v2.n3783 vss_1v2.n3782 0.00122751
R9693 vss_1v2.n3785 vss_1v2.n3784 0.00122751
R9694 vss_1v2.n3787 vss_1v2.n3786 0.00122751
R9695 vss_1v2.n3789 vss_1v2.n3788 0.00122751
R9696 vss_1v2.n3791 vss_1v2.n3790 0.00122751
R9697 vss_1v2.n3793 vss_1v2.n3792 0.00122751
R9698 vss_1v2.n3795 vss_1v2.n3794 0.00122751
R9699 vss_1v2.n3797 vss_1v2.n3796 0.00122751
R9700 vss_1v2.n3799 vss_1v2.n3798 0.00122751
R9701 vss_1v2.n3801 vss_1v2.n3800 0.00122751
R9702 vss_1v2.n3803 vss_1v2.n3802 0.00122751
R9703 vss_1v2.n3805 vss_1v2.n3804 0.00122751
R9704 vss_1v2.n3807 vss_1v2.n3806 0.00122751
R9705 vss_1v2.n3809 vss_1v2.n3808 0.00122751
R9706 vss_1v2.n4106 vss_1v2.n728 0.00122751
R9707 vss_1v2.n3589 vss_1v2.n2658 0.00122368
R9708 vss_1v2.n1855 vss_1v2.n714 0.00121825
R9709 vss_1v2.n1922 vss_1v2.n1849 0.00118358
R9710 vss_1v2.n3360 vss_1v2.n3358 0.00117381
R9711 vss_1v2.n3363 vss_1v2.n3362 0.00117381
R9712 vss_1v2.n3355 vss_1v2.n3353 0.00117381
R9713 vss_1v2.n3372 vss_1v2.n3371 0.00117381
R9714 vss_1v2.n3379 vss_1v2.n3378 0.00117381
R9715 vss_1v2.n3380 vss_1v2.n3348 0.00117381
R9716 vss_1v2.n3383 vss_1v2.n3382 0.00117381
R9717 vss_1v2.n3386 vss_1v2.n3385 0.00117381
R9718 vss_1v2.n423 vss_1v2.n3387 0.00117381
R9719 vss_1v2.n3462 vss_1v2.n3460 0.00117381
R9720 vss_1v2.n3466 vss_1v2.n3464 0.00117381
R9721 vss_1v2.n3469 vss_1v2.n3468 0.00117381
R9722 vss_1v2.n3471 vss_1v2.n3457 0.00117381
R9723 vss_1v2.n4019 vss_1v2.n4018 0.00111766
R9724 vss_1v2.n1645 vss_1v2.n675 0.00108201
R9725 vss_1v2.n1604 vss_1v2.n666 0.00108201
R9726 vss_1v2.n1685 vss_1v2.n653 0.00108201
R9727 vss_1v2.n1702 vss_1v2.n644 0.00108201
R9728 vss_1v2.n1560 vss_1v2.n633 0.00108201
R9729 vss_1v2.n1740 vss_1v2.n624 0.00108201
R9730 vss_1v2.n1539 vss_1v2.n611 0.00108201
R9731 vss_1v2.n1526 vss_1v2.n602 0.00108201
R9732 vss_1v2.n1807 vss_1v2.n589 0.00108201
R9733 vss_1v2.n1507 vss_1v2.n580 0.00108201
R9734 vss_1v2.n1489 vss_1v2.n570 0.00108201
R9735 vss_1v2.n1479 vss_1v2.n1003 0.00108201
R9736 vss_1v2.n1000 vss_1v2.n560 0.00108201
R9737 vss_1v2.n1128 vss_1v2.n996 0.00108201
R9738 vss_1v2.n1111 vss_1v2.n548 0.00108201
R9739 vss_1v2.n1146 vss_1v2.n991 0.00108201
R9740 vss_1v2.n1097 vss_1v2.n538 0.00108201
R9741 vss_1v2.n986 vss_1v2.n532 0.00108201
R9742 vss_1v2.n1031 vss_1v2.n898 0.00108201
R9743 vss_1v2.n984 vss_1v2.n530 0.00108201
R9744 vss_1v2.n1033 vss_1v2.n900 0.00108201
R9745 vss_1v2.n982 vss_1v2.n528 0.00108201
R9746 vss_1v2.n1035 vss_1v2.n902 0.00108201
R9747 vss_1v2.n980 vss_1v2.n526 0.00108201
R9748 vss_1v2.n1037 vss_1v2.n904 0.00108201
R9749 vss_1v2.n978 vss_1v2.n524 0.00108201
R9750 vss_1v2.n1039 vss_1v2.n906 0.00108201
R9751 vss_1v2.n976 vss_1v2.n522 0.00108201
R9752 vss_1v2.n1041 vss_1v2.n908 0.00108201
R9753 vss_1v2.n974 vss_1v2.n520 0.00108201
R9754 vss_1v2.n1043 vss_1v2.n910 0.00108201
R9755 vss_1v2.n972 vss_1v2.n518 0.00108201
R9756 vss_1v2.n1045 vss_1v2.n912 0.00108201
R9757 vss_1v2.n1186 vss_1v2.n1045 0.00108201
R9758 vss_1v2.n970 vss_1v2.n516 0.00108201
R9759 vss_1v2.n1047 vss_1v2.n914 0.00108201
R9760 vss_1v2.n1076 vss_1v2.n514 0.00108201
R9761 vss_1v2.n968 vss_1v2.n514 0.00108201
R9762 vss_1v2.n1049 vss_1v2.n916 0.00108201
R9763 vss_1v2.n966 vss_1v2.n512 0.00108201
R9764 vss_1v2.n1051 vss_1v2.n918 0.00108201
R9765 vss_1v2.n965 vss_1v2.n510 0.00108201
R9766 vss_1v2.n1053 vss_1v2.n920 0.00108201
R9767 vss_1v2.n963 vss_1v2.n508 0.00108201
R9768 vss_1v2.n1055 vss_1v2.n922 0.00108201
R9769 vss_1v2.n961 vss_1v2.n506 0.00108201
R9770 vss_1v2.n1057 vss_1v2.n924 0.00108201
R9771 vss_1v2.n959 vss_1v2.n504 0.00108201
R9772 vss_1v2.n1214 vss_1v2.n926 0.00108201
R9773 vss_1v2.n957 vss_1v2.n502 0.00108201
R9774 vss_1v2.n1216 vss_1v2.n928 0.00108201
R9775 vss_1v2.n955 vss_1v2.n500 0.00108201
R9776 vss_1v2.n4136 vss_1v2.n930 0.00108201
R9777 vss_1v2.n953 vss_1v2.n498 0.00108201
R9778 vss_1v2.n1219 vss_1v2.n932 0.00108201
R9779 vss_1v2.n940 vss_1v2.n496 0.00108201
R9780 vss_1v2.n4147 vss_1v2.n938 0.00108201
R9781 vss_1v2.n3655 vss_1v2.n3654 0.00108201
R9782 vss_1v2.n2609 vss_1v2.n2608 0.00108201
R9783 vss_1v2.n3712 vss_1v2.n2589 0.00108201
R9784 vss_1v2.n2545 vss_1v2.n2544 0.00108201
R9785 vss_1v2.n1921 vss_1v2.n1860 0.00106965
R9786 vss_1v2.n0 vss_1v2.n40 0.00943972
R9787 vss_1v2.n353 vss_1v2.n352 0.00336713
R9788 vss_1v2.n3111 vss_1v2.n354 0.00169627
R9789 vss_1v2.n3057 vss_1v2.n39 0.00106965
R9790 vss_1v2.n2911 vss_1v2.n2909 0.00106151
R9791 vss_1v2.n3486 vss_1v2.n2907 0.00106151
R9792 vss_1v2.n2443 vss_1v2.n2000 0.00105615
R9793 vss_1v2.n4135 vss_1v2.n1008 0.001
R9794 vss_1v2.n4133 vss_1v2.n1275 0.001
R9795 vss_1v2.n3189 vss_1v2.n1008 0.001
R9796 vss_1v2.n1287 vss_1v2.n1275 0.001
R9797 vss_1v2.n4135 vss_1v2.n951 0.001
R9798 vss_1v2.n3315 vss_1v2.n3314 0.001
R9799 vss_1v2.n3319 vss_1v2.n3317 0.001
R9800 vss_1v2.n3321 vss_1v2.n3320 0.001
R9801 vss_1v2.n3322 vss_1v2.n1272 0.001
R9802 vss_1v2.n3314 vss_1v2.n951 0.001
R9803 vss_1v2.n3317 vss_1v2.n3315 0.001
R9804 vss_1v2.n3320 vss_1v2.n3319 0.001
R9805 vss_1v2.n3322 vss_1v2.n3321 0.001
R9806 vss_1v2.n4133 vss_1v2.n1272 0.001
R9807 vss_1v2.n3169 vss_1v2.n1285 0.001
R9808 vss_1v2.n3168 vss_1v2.n3167 0.001
R9809 vss_1v2.n1290 vss_1v2.n1289 0.001
R9810 vss_1v2.n4133 vss_1v2.n1251 0.001
R9811 vss_1v2.n1289 vss_1v2.n1251 0.001
R9812 vss_1v2.n3182 vss_1v2.n1290 0.001
R9813 vss_1v2.n3169 vss_1v2.n3168 0.001
R9814 vss_1v2.n3171 vss_1v2.n1285 0.001
R9815 vss_1v2.n4133 vss_1v2.n1224 0.001
R9816 vss_1v2.n3231 vss_1v2.n3230 0.001
R9817 vss_1v2.n3231 vss_1v2.n2832 0.001
R9818 vss_1v2.n3215 vss_1v2.n2833 0.001
R9819 vss_1v2.n3214 vss_1v2.n3213 0.001
R9820 vss_1v2.n3213 vss_1v2.n2830 0.001
R9821 vss_1v2.n3239 vss_1v2.n1224 0.001
R9822 vss_1v2.n3234 vss_1v2.n2832 0.001
R9823 vss_1v2.n3230 vss_1v2.n3229 0.001
R9824 vss_1v2.n3229 vss_1v2.n2833 0.001
R9825 vss_1v2.n3215 vss_1v2.n3214 0.001
R9826 vss_1v2.n3209 vss_1v2.n2830 0.001
R9827 vss_1v2.n3166 vss_1v2.n3165 0.001
R9828 vss_1v2.n3136 vss_1v2.n3135 0.001
R9829 vss_1v2.n3136 vss_1v2.n2834 0.001
R9830 vss_1v2.n3144 vss_1v2.n2829 0.001
R9831 vss_1v2.n3143 vss_1v2.n2828 0.001
R9832 vss_1v2.n3209 vss_1v2.n3166 0.001
R9833 vss_1v2.n3165 vss_1v2.n2834 0.001
R9834 vss_1v2.n3135 vss_1v2.n3134 0.001
R9835 vss_1v2.n3140 vss_1v2.n2829 0.001
R9836 vss_1v2.n3144 vss_1v2.n3143 0.001
R9837 vss_1v2.n2993 vss_1v2.n2992 0.001
R9838 vss_1v2.n3006 vss_1v2.n1293 0.001
R9839 vss_1v2.n3005 vss_1v2.n3004 0.001
R9840 vss_1v2.n3002 vss_1v2.n1292 0.001
R9841 vss_1v2.n3002 vss_1v2.n3001 0.001
R9842 vss_1v2.n3001 vss_1v2.n3000 0.001
R9843 vss_1v2.n3004 vss_1v2.n1292 0.001
R9844 vss_1v2.n3006 vss_1v2.n3005 0.001
R9845 vss_1v2.n3008 vss_1v2.n1293 0.001
R9846 vss_1v2.n2992 vss_1v2.n2828 0.001
R9847 vss_1v2.n3079 vss_1v2.n1294 0.001
R9848 vss_1v2.n3079 vss_1v2.n3078 0.001
R9849 vss_1v2.n3119 vss_1v2.n3118 0.001
R9850 vss_1v2.n3116 vss_1v2.n1281 0.001
R9851 vss_1v2.n3116 vss_1v2.n3115 0.001
R9852 vss_1v2.n3027 vss_1v2.n1282 0.001
R9853 vss_1v2.n3027 vss_1v2.n3026 0.001
R9854 vss_1v2.n2828 vss_1v2.n1283 0.001
R9855 vss_1v2.n3025 vss_1v2.n1283 0.001
R9856 vss_1v2.n3026 vss_1v2.n3025 0.001
R9857 vss_1v2.n3114 vss_1v2.n1282 0.001
R9858 vss_1v2.n3115 vss_1v2.n3114 0.001
R9859 vss_1v2.n3118 vss_1v2.n1281 0.001
R9860 vss_1v2.n3120 vss_1v2.n3119 0.001
R9861 vss_1v2.n3120 vss_1v2.n1294 0.001
R9862 vss_1v2.n3078 vss_1v2.n1295 0.001
R9863 vss_1v2.n2895 vss_1v2.n2828 0.001
R9864 vss_1v2.n2892 vss_1v2.n2827 0.001
R9865 vss_1v2.n2891 vss_1v2.n2890 0.001
R9866 vss_1v2.n3059 vss_1v2.n2836 0.001
R9867 vss_1v2.n3061 vss_1v2.n3060 0.001
R9868 vss_1v2.n2896 vss_1v2.n2895 0.001
R9869 vss_1v2.n2896 vss_1v2.n2827 0.001
R9870 vss_1v2.n2892 vss_1v2.n2891 0.001
R9871 vss_1v2.n3092 vss_1v2.n2836 0.001
R9872 vss_1v2.n3060 vss_1v2.n3059 0.001
R9873 vss_1v2.n3061 vss_1v2.n2837 0.001
R9874 vss_1v2.n2687 vss_1v2.n1295 0.001
R9875 vss_1v2.n2837 vss_1v2.n1295 0.001
R9876 vss_1v2.n3578 vss_1v2.n3577 0.001
R9877 vss_1v2.n3577 vss_1v2.n2685 0.001
R9878 vss_1v2.n3560 vss_1v2.n3559 0.001
R9879 vss_1v2.n2816 vss_1v2.n1965 0.001
R9880 vss_1v2.n2688 vss_1v2.n2687 0.001
R9881 vss_1v2.n2688 vss_1v2.n2685 0.001
R9882 vss_1v2.n3579 vss_1v2.n3578 0.001
R9883 vss_1v2.n3559 vss_1v2.n2824 0.001
R9884 vss_1v2.n3560 vss_1v2.n2816 0.001
R9885 vss_1v2.n3046 vss_1v2.n1277 0.001
R9886 vss_1v2.n3048 vss_1v2.n3047 0.001
R9887 vss_1v2.n3051 vss_1v2.n1278 0.001
R9888 vss_1v2.n3053 vss_1v2.n3052 0.001
R9889 vss_1v2.n3034 vss_1v2.n1279 0.001
R9890 vss_1v2.n3038 vss_1v2.n3034 0.001
R9891 vss_1v2.n3036 vss_1v2.n1280 0.001
R9892 vss_1v2.n3035 vss_1v2.n1295 0.001
R9893 vss_1v2.n3036 vss_1v2.n3035 0.001
R9894 vss_1v2.n3039 vss_1v2.n1280 0.001
R9895 vss_1v2.n3039 vss_1v2.n3038 0.001
R9896 vss_1v2.n3053 vss_1v2.n1279 0.001
R9897 vss_1v2.n3052 vss_1v2.n3051 0.001
R9898 vss_1v2.n3048 vss_1v2.n1278 0.001
R9899 vss_1v2.n3047 vss_1v2.n3046 0.001
R9900 vss_1v2.n3044 vss_1v2.n1277 0.001
R9901 vss_1v2.n3044 vss_1v2.n3043 0.001
R9902 vss_1v2.n3043 vss_1v2.n1965 0.001
R9903 vss_1v2.n1965 vss_1v2.n261 0.00124999
R9904 vss_1v2.n1301 vss_1v2.n219 0.001
R9905 vss_1v2.n260 vss_1v2.n5 0.00166667
R9906 vss_1v2.n3556 vss_1v2.n220 0.001
R9907 vss_1v2.n3557 vss_1v2.n3556 0.001
R9908 vss_1v2.n3557 vss_1v2.n2850 0.001
R9909 vss_1v2.n260 vss_1v2.n220 0.001
R9910 vss_1v2.n3540 vss_1v2.n1985 0.001
R9911 vss_1v2.n3546 vss_1v2.n1986 0.001
R9912 vss_1v2.n3556 vss_1v2.n1987 0.001
R9913 vss_1v2.n3546 vss_1v2.n1987 0.001
R9914 vss_1v2.n3540 vss_1v2.n1986 0.001
R9915 vss_1v2.n3507 vss_1v2.n418 0.001
R9916 vss_1v2.n3513 vss_1v2.n3512 0.001
R9917 vss_1v2.n3518 vss_1v2.n2864 0.001
R9918 vss_1v2.n3522 vss_1v2.n3521 0.001
R9919 vss_1v2.n3528 vss_1v2.n3526 0.001
R9920 vss_1v2.n3549 vss_1v2.n2851 0.001
R9921 vss_1v2.n12 vss_1v2.n936 0.001
R9922 vss_1v2.n3508 vss_1v2.n2866 0.001
R9923 vss_1v2.n3514 vss_1v2.n3513 0.001
R9924 vss_1v2.n3519 vss_1v2.n3518 0.001
R9925 vss_1v2.n3523 vss_1v2.n3522 0.001
R9926 vss_1v2.n3531 vss_1v2.n3529 0.001
R9927 vss_1v2.n2860 vss_1v2.n2859 0.001
R9928 vss_1v2.n3551 vss_1v2.n3550 0.001
R9929 vss_1v2.n81 vss_1v2.n80 0.00162399
R9930 vss_1v2.n2674 vss_1v2.n2673 0.001
R9931 vss_1v2.n2673 vss_1v2.n2664 0.001
R9932 vss_1v2.n308 vss_1v2.n350 0.001
R9933 vss_1v2.n3341 vss_1v2.n309 0.001
R9934 vss_1v2.n3146 vss_1v2.n2807 0.001
R9935 vss_1v2.n3159 vss_1v2.n2672 0.001
R9936 vss_1v2.n3159 vss_1v2.n2696 0.001
R9937 vss_1v2.n3487 vss_1v2.n2899 0.001
R9938 vss_1v2.n3505 vss_1v2.n2668 0.001
R9939 vss_1v2.n3503 vss_1v2.n2809 0.001
R9940 vss_1v2.n3501 vss_1v2.n2669 0.001
R9941 vss_1v2.n3501 vss_1v2.n2694 0.001
R9942 vss_1v2.n3571 vss_1v2.n2667 0.001
R9943 vss_1v2.n3571 vss_1v2.n3570 0.001
R9944 vss_1v2.n4030 vss_1v2.n4029 0.001
R9945 vss_1v2.n2693 vss_1v2.n1968 0.001
R9946 vss_1v2.n2512 vss_1v2.n2096 0.001
R9947 vss_1v2.n3833 vss_1v2.n3832 0.001
R9948 vss_1v2.n2521 vss_1v2.n2452 0.001
R9949 vss_1v2.n2520 vss_1v2.n2453 0.001
R9950 vss_1v2.n2519 vss_1v2.n2454 0.001
R9951 vss_1v2.n2513 vss_1v2.n2504 0.001
R9952 vss_1v2.n2456 vss_1v2.n2447 0.001
R9953 vss_1v2.n2514 vss_1v2.n2503 0.001
R9954 vss_1v2.n2515 vss_1v2.n2502 0.001
R9955 vss_1v2.n2516 vss_1v2.n2501 0.001
R9956 vss_1v2.n2518 vss_1v2.n2461 0.001
R9957 vss_1v2.n3837 vss_1v2.n3836 0.001
R9958 vss_1v2.n3818 vss_1v2.n2096 0.001
R9959 vss_1v2.n3828 vss_1v2.n2452 0.001
R9960 vss_1v2.n3827 vss_1v2.n2453 0.001
R9961 vss_1v2.n3826 vss_1v2.n2454 0.001
R9962 vss_1v2.n3819 vss_1v2.n2505 0.001
R9963 vss_1v2.n3825 vss_1v2.n2456 0.001
R9964 vss_1v2.n3839 vss_1v2.n2448 0.001
R9965 vss_1v2.n3824 vss_1v2.n2458 0.001
R9966 vss_1v2.n3820 vss_1v2.n2502 0.001
R9967 vss_1v2.n3823 vss_1v2.n2460 0.001
R9968 vss_1v2.n3821 vss_1v2.n418 0.001
R9969 vss_1v2.n3815 vss_1v2.n2095 0.001
R9970 vss_1v2.n3815 vss_1v2.n2356 0.001
R9971 vss_1v2.n2355 vss_1v2.n2354 0.001
R9972 vss_1v2.n2239 vss_1v2.n2094 0.001
R9973 vss_1v2.n2358 vss_1v2.n2094 0.001
R9974 vss_1v2.n2240 vss_1v2.n459 0.001
R9975 vss_1v2.n2359 vss_1v2.n459 0.001
R9976 vss_1v2.n2241 vss_1v2.n378 0.001
R9977 vss_1v2.n2360 vss_1v2.n378 0.001
R9978 vss_1v2.n3361 vss_1v2.n2100 0.001
R9979 vss_1v2.n3361 vss_1v2.n2361 0.001
R9980 vss_1v2.n2363 vss_1v2.n2362 0.001
R9981 vss_1v2.n2238 vss_1v2.n2101 0.001
R9982 vss_1v2.n2353 vss_1v2.n2101 0.001
R9983 vss_1v2.n2237 vss_1v2.n461 0.001
R9984 vss_1v2.n2352 vss_1v2.n461 0.001
R9985 vss_1v2.n2236 vss_1v2.n480 0.001
R9986 vss_1v2.n2351 vss_1v2.n480 0.001
R9987 vss_1v2.n2235 vss_1v2.n469 0.001
R9988 vss_1v2.n2350 vss_1v2.n469 0.001
R9989 vss_1v2.n3374 vss_1v2.n2092 0.001
R9990 vss_1v2.n3374 vss_1v2.n2349 0.001
R9991 vss_1v2.n472 vss_1v2.n2348 0.001
R9992 vss_1v2.n2242 vss_1v2.n2091 0.001
R9993 vss_1v2.n2364 vss_1v2.n2091 0.001
R9994 vss_1v2.n2243 vss_1v2.n2090 0.001
R9995 vss_1v2.n2365 vss_1v2.n2090 0.001
R9996 vss_1v2.n2244 vss_1v2.n2089 0.001
R9997 vss_1v2.n2366 vss_1v2.n2089 0.001
R9998 vss_1v2.n3388 vss_1v2.n2105 0.001
R9999 vss_1v2.n3388 vss_1v2.n2367 0.001
R10000 vss_1v2.n2369 vss_1v2.n2368 0.001
R10001 vss_1v2.n2234 vss_1v2.n2106 0.001
R10002 vss_1v2.n2347 vss_1v2.n2106 0.001
R10003 vss_1v2.n2233 vss_1v2.n2107 0.001
R10004 vss_1v2.n2346 vss_1v2.n2107 0.001
R10005 vss_1v2.n2232 vss_1v2.n2108 0.001
R10006 vss_1v2.n2345 vss_1v2.n2108 0.001
R10007 vss_1v2.n2231 vss_1v2.n2109 0.001
R10008 vss_1v2.n2344 vss_1v2.n2109 0.001
R10009 vss_1v2.n2910 vss_1v2.n2083 0.001
R10010 vss_1v2.n2910 vss_1v2.n2343 0.001
R10011 vss_1v2.n2342 vss_1v2.n2341 0.001
R10012 vss_1v2.n2245 vss_1v2.n475 0.001
R10013 vss_1v2.n2370 vss_1v2.n475 0.001
R10014 vss_1v2.n2246 vss_1v2.n477 0.001
R10015 vss_1v2.n2371 vss_1v2.n477 0.001
R10016 vss_1v2.n2247 vss_1v2.n2082 0.001
R10017 vss_1v2.n2372 vss_1v2.n2082 0.001
R10018 vss_1v2.n3397 vss_1v2.n2112 0.001
R10019 vss_1v2.n3397 vss_1v2.n2373 0.001
R10020 vss_1v2.n2375 vss_1v2.n2374 0.001
R10021 vss_1v2.n2230 vss_1v2.n2113 0.001
R10022 vss_1v2.n2340 vss_1v2.n2113 0.001
R10023 vss_1v2.n2229 vss_1v2.n451 0.001
R10024 vss_1v2.n2339 vss_1v2.n451 0.001
R10025 vss_1v2.n3452 vss_1v2.n2079 0.001
R10026 vss_1v2.n3452 vss_1v2.n2338 0.001
R10027 vss_1v2.n454 vss_1v2.n2337 0.001
R10028 vss_1v2.n2248 vss_1v2.n2078 0.001
R10029 vss_1v2.n2376 vss_1v2.n2078 0.001
R10030 vss_1v2.n2249 vss_1v2.n2077 0.001
R10031 vss_1v2.n2377 vss_1v2.n2077 0.001
R10032 vss_1v2.n2250 vss_1v2.n2076 0.001
R10033 vss_1v2.n2378 vss_1v2.n2076 0.001
R10034 vss_1v2.n2251 vss_1v2.n2075 0.001
R10035 vss_1v2.n2379 vss_1v2.n2075 0.001
R10036 vss_1v2.n3465 vss_1v2.n2123 0.001
R10037 vss_1v2.n3465 vss_1v2.n2380 0.001
R10038 vss_1v2.n2382 vss_1v2.n2381 0.001
R10039 vss_1v2.n2228 vss_1v2.n2124 0.001
R10040 vss_1v2.n2336 vss_1v2.n2124 0.001
R10041 vss_1v2.n2227 vss_1v2.n2125 0.001
R10042 vss_1v2.n2335 vss_1v2.n2125 0.001
R10043 vss_1v2.n2126 vss_1v2.n2002 0.001
R10044 vss_1v2.n2334 vss_1v2.n2126 0.001
R10045 vss_1v2.n3810 vss_1v2.n372 0.00166667
R10046 vss_1v2.n3359 vss_1v2.n2524 0.001
R10047 vss_1v2.n3359 vss_1v2.n3356 0.001
R10048 vss_1v2.n3368 vss_1v2.n3367 0.001
R10049 vss_1v2.n3369 vss_1v2.n3368 0.001
R10050 vss_1v2.n3354 vss_1v2.n462 0.001
R10051 vss_1v2.n3352 vss_1v2.n470 0.001
R10052 vss_1v2.n2937 vss_1v2.n470 0.001
R10053 vss_1v2.n2978 vss_1v2.n465 0.001
R10054 vss_1v2.n3485 vss_1v2.n2906 0.001
R10055 vss_1v2.n2929 vss_1v2.n2870 0.001
R10056 vss_1v2.n3445 vss_1v2.n2932 0.001
R10057 vss_1v2.n3445 vss_1v2.n2951 0.001
R10058 vss_1v2.n3436 vss_1v2.n1971 0.001
R10059 vss_1v2.n3436 vss_1v2.n2950 0.001
R10060 vss_1v2.n2930 vss_1v2.n1972 0.001
R10061 vss_1v2.n3480 vss_1v2.n2943 0.001
R10062 vss_1v2.n3481 vss_1v2.n1968 0.001
R10063 vss_1v2.n3475 vss_1v2.n2943 0.001
R10064 vss_1v2.n3481 vss_1v2.n3480 0.001
R10065 vss_1v2.n4029 vss_1v2.n1968 0.001
R10066 vss_1v2.n4030 vss_1v2.n1972 0.001
R10067 vss_1v2.n2691 vss_1v2.n2668 0.001
R10068 vss_1v2.n3570 vss_1v2.n2691 0.001
R10069 vss_1v2.n3573 vss_1v2.n2667 0.001
R10070 vss_1v2.n3562 vss_1v2.n2693 0.001
R10071 vss_1v2.n3505 vss_1v2.n2870 0.001
R10072 vss_1v2.n3442 vss_1v2.n2951 0.001
R10073 vss_1v2.n3439 vss_1v2.n2932 0.001
R10074 vss_1v2.n3439 vss_1v2.n2950 0.001
R10075 vss_1v2.n4030 vss_1v2.n1971 0.001
R10076 vss_1v2.n2899 vss_1v2.n2867 0.001
R10077 vss_1v2.n3487 vss_1v2.n2906 0.001
R10078 vss_1v2.n3161 vss_1v2.n350 0.001
R10079 vss_1v2.n3161 vss_1v2.n2696 0.001
R10080 vss_1v2.n3157 vss_1v2.n2672 0.001
R10081 vss_1v2.n2867 vss_1v2.n2807 0.001
R10082 vss_1v2.n3498 vss_1v2.n2694 0.001
R10083 vss_1v2.n3503 vss_1v2.n2669 0.001
R10084 vss_1v2.n3505 vss_1v2.n2809 0.001
R10085 vss_1v2.n3373 vss_1v2.n2937 0.001
R10086 vss_1v2.n2697 vss_1v2.n303 0.001
R10087 vss_1v2.n3352 vss_1v2.n462 0.001
R10088 vss_1v2.n462 vss_1v2.n2697 0.001
R10089 vss_1v2.n3810 vss_1v2.n2524 0.001
R10090 vss_1v2.n3364 vss_1v2.n3356 0.001
R10091 vss_1v2.n3367 vss_1v2.n3364 0.001
R10092 vss_1v2.n3370 vss_1v2.n3369 0.001
R10093 vss_1v2.n3370 vss_1v2.n3354 0.001
R10094 vss_1v2.n372 vss_1v2.n457 0.00133332
R10095 vss_1v2.n3587 vss_1v2.n2664 0.001
R10096 vss_1v2.n462 vss_1v2.n2674 0.001
R10097 vss_1v2.n3551 vss_1v2.n936 0.001
R10098 vss_1v2.n3550 vss_1v2.n3549 0.001
R10099 vss_1v2.n2852 vss_1v2.n2851 0.001
R10100 vss_1v2.n3537 vss_1v2.n2860 0.001
R10101 vss_1v2.n3529 vss_1v2.n3528 0.001
R10102 vss_1v2.n3526 vss_1v2.n3525 0.001
R10103 vss_1v2.n3525 vss_1v2.n3523 0.001
R10104 vss_1v2.n3521 vss_1v2.n3520 0.001
R10105 vss_1v2.n3520 vss_1v2.n3519 0.001
R10106 vss_1v2.n3515 vss_1v2.n2864 0.001
R10107 vss_1v2.n3515 vss_1v2.n3514 0.001
R10108 vss_1v2.n3512 vss_1v2.n3511 0.001
R10109 vss_1v2.n3511 vss_1v2.n2866 0.001
R10110 vss_1v2.n3508 vss_1v2.n3507 0.001
R10111 vss_1v2.n3821 vss_1v2.n2461 0.001
R10112 vss_1v2.n2518 vss_1v2.n2499 0.001
R10113 vss_1v2.n3823 vss_1v2.n2501 0.001
R10114 vss_1v2.n2516 vss_1v2.n2459 0.001
R10115 vss_1v2.n3820 vss_1v2.n2459 0.001
R10116 vss_1v2.n2515 vss_1v2.n2458 0.001
R10117 vss_1v2.n3824 vss_1v2.n2503 0.001
R10118 vss_1v2.n2514 vss_1v2.n2457 0.001
R10119 vss_1v2.n2457 vss_1v2.n2448 0.001
R10120 vss_1v2.n3839 vss_1v2.n2447 0.001
R10121 vss_1v2.n3825 vss_1v2.n2504 0.001
R10122 vss_1v2.n2513 vss_1v2.n2455 0.001
R10123 vss_1v2.n3819 vss_1v2.n2455 0.001
R10124 vss_1v2.n2519 vss_1v2.n2505 0.001
R10125 vss_1v2.n3826 vss_1v2.n2507 0.001
R10126 vss_1v2.n2520 vss_1v2.n2507 0.001
R10127 vss_1v2.n3827 vss_1v2.n2510 0.001
R10128 vss_1v2.n2521 vss_1v2.n2510 0.001
R10129 vss_1v2.n3833 vss_1v2.n3828 0.001
R10130 vss_1v2.n3832 vss_1v2.n2451 0.001
R10131 vss_1v2.n3818 vss_1v2.n2451 0.001
R10132 vss_1v2.n2512 vss_1v2.n2450 0.001
R10133 vss_1v2.n3836 vss_1v2.n2450 0.001
R10134 vss_1v2.n4121 vss_1v2.n1854 0.001
R10135 vss_1v2.n4124 vss_1v2.n4122 0.001
R10136 vss_1v2.n4127 vss_1v2.n4126 0.001
R10137 vss_1v2.n12 vss_1v2.n718 0.001
R10138 vss_1v2.n4127 vss_1v2.n718 0.001
R10139 vss_1v2.n4126 vss_1v2.n4122 0.001
R10140 vss_1v2.n4124 vss_1v2.n4121 0.001
R10141 vss_1v2.n4129 vss_1v2.n1854 0.001
R10142 vss_1v2.n4129 vss_1v2.n1879 0.001
R10143 vss_1v2.n3844 vss_1v2.n2001 0.001
R10144 vss_1v2.n2333 vss_1v2.n2127 0.001
R10145 vss_1v2.n2333 vss_1v2.n2332 0.001
R10146 vss_1v2.n3848 vss_1v2.n2383 0.001
R10147 vss_1v2.n2385 vss_1v2.n2071 0.001
R10148 vss_1v2.n2385 vss_1v2.n2384 0.001
R10149 vss_1v2.n2331 vss_1v2.n2129 0.001
R10150 vss_1v2.n2252 vss_1v2.n2069 0.001
R10151 vss_1v2.n2226 vss_1v2.n2130 0.001
R10152 vss_1v2.n2330 vss_1v2.n2130 0.001
R10153 vss_1v2.n3856 vss_1v2.n2329 0.001
R10154 vss_1v2.n2328 vss_1v2.n2131 0.001
R10155 vss_1v2.n2328 vss_1v2.n2327 0.001
R10156 vss_1v2.n2386 vss_1v2.n2067 0.001
R10157 vss_1v2.n2225 vss_1v2.n2133 0.001
R10158 vss_1v2.n2253 vss_1v2.n2066 0.001
R10159 vss_1v2.n2387 vss_1v2.n2066 0.001
R10160 vss_1v2.n2388 vss_1v2.n2065 0.001
R10161 vss_1v2.n2224 vss_1v2.n2135 0.001
R10162 vss_1v2.n2254 vss_1v2.n2064 0.001
R10163 vss_1v2.n2389 vss_1v2.n2064 0.001
R10164 vss_1v2.n2390 vss_1v2.n2063 0.001
R10165 vss_1v2.n2223 vss_1v2.n2137 0.001
R10166 vss_1v2.n2255 vss_1v2.n2062 0.001
R10167 vss_1v2.n2391 vss_1v2.n2062 0.001
R10168 vss_1v2.n2392 vss_1v2.n2061 0.001
R10169 vss_1v2.n2222 vss_1v2.n2139 0.001
R10170 vss_1v2.n2256 vss_1v2.n2060 0.001
R10171 vss_1v2.n2393 vss_1v2.n2060 0.001
R10172 vss_1v2.n2257 vss_1v2.n2059 0.001
R10173 vss_1v2.n2394 vss_1v2.n2059 0.001
R10174 vss_1v2.n2258 vss_1v2.n2058 0.001
R10175 vss_1v2.n2395 vss_1v2.n2058 0.001
R10176 vss_1v2.n2259 vss_1v2.n2057 0.001
R10177 vss_1v2.n2396 vss_1v2.n2057 0.001
R10178 vss_1v2.n2260 vss_1v2.n2056 0.001
R10179 vss_1v2.n2397 vss_1v2.n2056 0.001
R10180 vss_1v2.n3884 vss_1v2.n2145 0.001
R10181 vss_1v2.n3884 vss_1v2.n2398 0.001
R10182 vss_1v2.n2400 vss_1v2.n2399 0.001
R10183 vss_1v2.n2221 vss_1v2.n2146 0.001
R10184 vss_1v2.n2326 vss_1v2.n2146 0.001
R10185 vss_1v2.n3890 vss_1v2.n2053 0.001
R10186 vss_1v2.n3890 vss_1v2.n2325 0.001
R10187 vss_1v2.n2324 vss_1v2.n2323 0.001
R10188 vss_1v2.n3894 vss_1v2.n2148 0.001
R10189 vss_1v2.n3894 vss_1v2.n2401 0.001
R10190 vss_1v2.n2403 vss_1v2.n2402 0.001
R10191 vss_1v2.n2220 vss_1v2.n2149 0.001
R10192 vss_1v2.n2322 vss_1v2.n2149 0.001
R10193 vss_1v2.n2321 vss_1v2.n2150 0.001
R10194 vss_1v2.n2320 vss_1v2.n2151 0.001
R10195 vss_1v2.n2320 vss_1v2.n2319 0.001
R10196 vss_1v2.n2261 vss_1v2.n2050 0.001
R10197 vss_1v2.n2404 vss_1v2.n2050 0.001
R10198 vss_1v2.n3906 vss_1v2.n2153 0.001
R10199 vss_1v2.n3906 vss_1v2.n2405 0.001
R10200 vss_1v2.n2407 vss_1v2.n2406 0.001
R10201 vss_1v2.n2219 vss_1v2.n2154 0.001
R10202 vss_1v2.n2318 vss_1v2.n2154 0.001
R10203 vss_1v2.n2218 vss_1v2.n2155 0.001
R10204 vss_1v2.n2317 vss_1v2.n2155 0.001
R10205 vss_1v2.n2217 vss_1v2.n2156 0.001
R10206 vss_1v2.n2316 vss_1v2.n2156 0.001
R10207 vss_1v2.n2216 vss_1v2.n2157 0.001
R10208 vss_1v2.n2315 vss_1v2.n2157 0.001
R10209 vss_1v2.n3918 vss_1v2.n2044 0.001
R10210 vss_1v2.n3918 vss_1v2.n2314 0.001
R10211 vss_1v2.n2313 vss_1v2.n2312 0.001
R10212 vss_1v2.n2262 vss_1v2.n2043 0.001
R10213 vss_1v2.n2408 vss_1v2.n2043 0.001
R10214 vss_1v2.n2263 vss_1v2.n2042 0.001
R10215 vss_1v2.n2409 vss_1v2.n2042 0.001
R10216 vss_1v2.n2264 vss_1v2.n2041 0.001
R10217 vss_1v2.n2410 vss_1v2.n2041 0.001
R10218 vss_1v2.n3928 vss_1v2.n2162 0.001
R10219 vss_1v2.n3928 vss_1v2.n2411 0.001
R10220 vss_1v2.n2413 vss_1v2.n2412 0.001
R10221 vss_1v2.n2215 vss_1v2.n2163 0.001
R10222 vss_1v2.n2311 vss_1v2.n2163 0.001
R10223 vss_1v2.n2214 vss_1v2.n2164 0.001
R10224 vss_1v2.n2310 vss_1v2.n2164 0.001
R10225 vss_1v2.n2213 vss_1v2.n2165 0.001
R10226 vss_1v2.n2309 vss_1v2.n2165 0.001
R10227 vss_1v2.n2212 vss_1v2.n2166 0.001
R10228 vss_1v2.n2308 vss_1v2.n2166 0.001
R10229 vss_1v2.n3940 vss_1v2.n2035 0.001
R10230 vss_1v2.n3940 vss_1v2.n2307 0.001
R10231 vss_1v2.n2306 vss_1v2.n2305 0.001
R10232 vss_1v2.n2265 vss_1v2.n2034 0.001
R10233 vss_1v2.n2414 vss_1v2.n2034 0.001
R10234 vss_1v2.n2266 vss_1v2.n2033 0.001
R10235 vss_1v2.n2415 vss_1v2.n2033 0.001
R10236 vss_1v2.n2267 vss_1v2.n2032 0.001
R10237 vss_1v2.n2416 vss_1v2.n2032 0.001
R10238 vss_1v2.n3950 vss_1v2.n2171 0.001
R10239 vss_1v2.n3950 vss_1v2.n2417 0.001
R10240 vss_1v2.n2419 vss_1v2.n2418 0.001
R10241 vss_1v2.n2211 vss_1v2.n2172 0.001
R10242 vss_1v2.n2304 vss_1v2.n2172 0.001
R10243 vss_1v2.n2210 vss_1v2.n2173 0.001
R10244 vss_1v2.n2303 vss_1v2.n2173 0.001
R10245 vss_1v2.n2209 vss_1v2.n2174 0.001
R10246 vss_1v2.n2302 vss_1v2.n2174 0.001
R10247 vss_1v2.n2208 vss_1v2.n2175 0.001
R10248 vss_1v2.n2301 vss_1v2.n2175 0.001
R10249 vss_1v2.n3962 vss_1v2.n2026 0.001
R10250 vss_1v2.n3962 vss_1v2.n2300 0.001
R10251 vss_1v2.n2299 vss_1v2.n2298 0.001
R10252 vss_1v2.n2268 vss_1v2.n2025 0.001
R10253 vss_1v2.n2420 vss_1v2.n2025 0.001
R10254 vss_1v2.n2269 vss_1v2.n2024 0.001
R10255 vss_1v2.n2421 vss_1v2.n2024 0.001
R10256 vss_1v2.n2270 vss_1v2.n2023 0.001
R10257 vss_1v2.n2422 vss_1v2.n2023 0.001
R10258 vss_1v2.n2271 vss_1v2.n2022 0.001
R10259 vss_1v2.n2423 vss_1v2.n2022 0.001
R10260 vss_1v2.n3974 vss_1v2.n2181 0.001
R10261 vss_1v2.n3974 vss_1v2.n2424 0.001
R10262 vss_1v2.n2426 vss_1v2.n2425 0.001
R10263 vss_1v2.n2207 vss_1v2.n2182 0.001
R10264 vss_1v2.n2297 vss_1v2.n2182 0.001
R10265 vss_1v2.n2206 vss_1v2.n2183 0.001
R10266 vss_1v2.n2296 vss_1v2.n2183 0.001
R10267 vss_1v2.n2205 vss_1v2.n2184 0.001
R10268 vss_1v2.n2295 vss_1v2.n2184 0.001
R10269 vss_1v2.n3984 vss_1v2.n2017 0.001
R10270 vss_1v2.n3984 vss_1v2.n2294 0.001
R10271 vss_1v2.n2293 vss_1v2.n2292 0.001
R10272 vss_1v2.n2272 vss_1v2.n2016 0.001
R10273 vss_1v2.n2427 vss_1v2.n2016 0.001
R10274 vss_1v2.n2273 vss_1v2.n2015 0.001
R10275 vss_1v2.n2428 vss_1v2.n2015 0.001
R10276 vss_1v2.n2274 vss_1v2.n2014 0.001
R10277 vss_1v2.n2429 vss_1v2.n2014 0.001
R10278 vss_1v2.n2275 vss_1v2.n2013 0.001
R10279 vss_1v2.n2430 vss_1v2.n2013 0.001
R10280 vss_1v2.n3996 vss_1v2.n2190 0.001
R10281 vss_1v2.n3996 vss_1v2.n2431 0.001
R10282 vss_1v2.n3999 vss_1v2.n2432 0.001
R10283 vss_1v2.n2204 vss_1v2.n2191 0.001
R10284 vss_1v2.n2291 vss_1v2.n2191 0.001
R10285 vss_1v2.n2203 vss_1v2.n2192 0.001
R10286 vss_1v2.n2290 vss_1v2.n2192 0.001
R10287 vss_1v2.n2202 vss_1v2.n2193 0.001
R10288 vss_1v2.n2289 vss_1v2.n2193 0.001
R10289 vss_1v2.n2201 vss_1v2.n2194 0.001
R10290 vss_1v2.n2288 vss_1v2.n2194 0.001
R10291 vss_1v2.n2286 vss_1v2.n2007 0.001
R10292 vss_1v2.n2287 vss_1v2.n2286 0.001
R10293 vss_1v2.n4004 vss_1v2.n2284 0.001
R10294 vss_1v2.n2276 vss_1v2.n2006 0.001
R10295 vss_1v2.n4000 vss_1v2.n2006 0.001
R10296 vss_1v2.n2277 vss_1v2.n2005 0.001
R10297 vss_1v2.n4001 vss_1v2.n2005 0.001
R10298 vss_1v2.n2278 vss_1v2.n2004 0.001
R10299 vss_1v2.n4002 vss_1v2.n2004 0.001
R10300 vss_1v2.n4015 vss_1v2.n4014 0.001
R10301 vss_1v2.n4014 vss_1v2.n2280 0.001
R10302 vss_1v2.n2200 vss_1v2.n2199 0.001
R10303 vss_1v2.n4129 vss_1v2.n1898 0.001
R10304 vss_1v2.n2356 vss_1v2.n2096 0.001
R10305 vss_1v2.n2355 vss_1v2.n2095 0.001
R10306 vss_1v2.n2354 vss_1v2.n2097 0.001
R10307 vss_1v2.n2358 vss_1v2.n2097 0.001
R10308 vss_1v2.n2239 vss_1v2.n2098 0.001
R10309 vss_1v2.n2359 vss_1v2.n2098 0.001
R10310 vss_1v2.n2240 vss_1v2.n460 0.001
R10311 vss_1v2.n2360 vss_1v2.n460 0.001
R10312 vss_1v2.n2241 vss_1v2.n2099 0.001
R10313 vss_1v2.n2361 vss_1v2.n2099 0.001
R10314 vss_1v2.n2363 vss_1v2.n2100 0.001
R10315 vss_1v2.n2362 vss_1v2.n2093 0.001
R10316 vss_1v2.n2353 vss_1v2.n2093 0.001
R10317 vss_1v2.n2238 vss_1v2.n368 0.001
R10318 vss_1v2.n2352 vss_1v2.n368 0.001
R10319 vss_1v2.n2237 vss_1v2.n463 0.001
R10320 vss_1v2.n2351 vss_1v2.n463 0.001
R10321 vss_1v2.n2236 vss_1v2.n482 0.001
R10322 vss_1v2.n2350 vss_1v2.n482 0.001
R10323 vss_1v2.n2235 vss_1v2.n471 0.001
R10324 vss_1v2.n2349 vss_1v2.n471 0.001
R10325 vss_1v2.n472 vss_1v2.n2092 0.001
R10326 vss_1v2.n2348 vss_1v2.n2102 0.001
R10327 vss_1v2.n2364 vss_1v2.n2102 0.001
R10328 vss_1v2.n2242 vss_1v2.n2103 0.001
R10329 vss_1v2.n2365 vss_1v2.n2103 0.001
R10330 vss_1v2.n2243 vss_1v2.n2104 0.001
R10331 vss_1v2.n2366 vss_1v2.n2104 0.001
R10332 vss_1v2.n2244 vss_1v2.n466 0.001
R10333 vss_1v2.n2367 vss_1v2.n466 0.001
R10334 vss_1v2.n2369 vss_1v2.n2105 0.001
R10335 vss_1v2.n2368 vss_1v2.n2088 0.001
R10336 vss_1v2.n2347 vss_1v2.n2088 0.001
R10337 vss_1v2.n2234 vss_1v2.n2087 0.001
R10338 vss_1v2.n2346 vss_1v2.n2087 0.001
R10339 vss_1v2.n2233 vss_1v2.n2086 0.001
R10340 vss_1v2.n2345 vss_1v2.n2086 0.001
R10341 vss_1v2.n2232 vss_1v2.n2085 0.001
R10342 vss_1v2.n2344 vss_1v2.n2085 0.001
R10343 vss_1v2.n2231 vss_1v2.n2084 0.001
R10344 vss_1v2.n2343 vss_1v2.n2084 0.001
R10345 vss_1v2.n2342 vss_1v2.n2083 0.001
R10346 vss_1v2.n2341 vss_1v2.n474 0.001
R10347 vss_1v2.n2370 vss_1v2.n474 0.001
R10348 vss_1v2.n2245 vss_1v2.n476 0.001
R10349 vss_1v2.n2371 vss_1v2.n476 0.001
R10350 vss_1v2.n2246 vss_1v2.n2110 0.001
R10351 vss_1v2.n2372 vss_1v2.n2110 0.001
R10352 vss_1v2.n2247 vss_1v2.n2111 0.001
R10353 vss_1v2.n2373 vss_1v2.n2111 0.001
R10354 vss_1v2.n2375 vss_1v2.n2112 0.001
R10355 vss_1v2.n2374 vss_1v2.n2081 0.001
R10356 vss_1v2.n2340 vss_1v2.n2081 0.001
R10357 vss_1v2.n2230 vss_1v2.n2080 0.001
R10358 vss_1v2.n2339 vss_1v2.n2080 0.001
R10359 vss_1v2.n2229 vss_1v2.n453 0.001
R10360 vss_1v2.n2338 vss_1v2.n453 0.001
R10361 vss_1v2.n454 vss_1v2.n2079 0.001
R10362 vss_1v2.n2337 vss_1v2.n2114 0.001
R10363 vss_1v2.n2376 vss_1v2.n2114 0.001
R10364 vss_1v2.n2248 vss_1v2.n2115 0.001
R10365 vss_1v2.n2377 vss_1v2.n2115 0.001
R10366 vss_1v2.n2249 vss_1v2.n2116 0.001
R10367 vss_1v2.n2378 vss_1v2.n2116 0.001
R10368 vss_1v2.n2250 vss_1v2.n2121 0.001
R10369 vss_1v2.n2379 vss_1v2.n2121 0.001
R10370 vss_1v2.n2251 vss_1v2.n2122 0.001
R10371 vss_1v2.n2380 vss_1v2.n2122 0.001
R10372 vss_1v2.n2382 vss_1v2.n2123 0.001
R10373 vss_1v2.n2381 vss_1v2.n2074 0.001
R10374 vss_1v2.n2336 vss_1v2.n2074 0.001
R10375 vss_1v2.n2228 vss_1v2.n2073 0.001
R10376 vss_1v2.n2335 vss_1v2.n2073 0.001
R10377 vss_1v2.n2227 vss_1v2.n2072 0.001
R10378 vss_1v2.n2334 vss_1v2.n2072 0.001
R10379 vss_1v2.n4017 vss_1v2.n2002 0.001
R10380 vss_1v2.n4017 vss_1v2.n2001 0.001
R10381 vss_1v2.n3844 vss_1v2.n2127 0.001
R10382 vss_1v2.n2332 vss_1v2.n2128 0.001
R10383 vss_1v2.n2383 vss_1v2.n2128 0.001
R10384 vss_1v2.n3848 vss_1v2.n2071 0.001
R10385 vss_1v2.n2384 vss_1v2.n2070 0.001
R10386 vss_1v2.n2331 vss_1v2.n2070 0.001
R10387 vss_1v2.n2252 vss_1v2.n2129 0.001
R10388 vss_1v2.n2330 vss_1v2.n2069 0.001
R10389 vss_1v2.n2226 vss_1v2.n2068 0.001
R10390 vss_1v2.n2329 vss_1v2.n2068 0.001
R10391 vss_1v2.n3856 vss_1v2.n2131 0.001
R10392 vss_1v2.n2327 vss_1v2.n2132 0.001
R10393 vss_1v2.n2386 vss_1v2.n2132 0.001
R10394 vss_1v2.n2225 vss_1v2.n2067 0.001
R10395 vss_1v2.n2387 vss_1v2.n2133 0.001
R10396 vss_1v2.n2253 vss_1v2.n2134 0.001
R10397 vss_1v2.n2388 vss_1v2.n2134 0.001
R10398 vss_1v2.n2224 vss_1v2.n2065 0.001
R10399 vss_1v2.n2389 vss_1v2.n2135 0.001
R10400 vss_1v2.n2254 vss_1v2.n2136 0.001
R10401 vss_1v2.n2390 vss_1v2.n2136 0.001
R10402 vss_1v2.n2223 vss_1v2.n2063 0.001
R10403 vss_1v2.n2391 vss_1v2.n2137 0.001
R10404 vss_1v2.n2255 vss_1v2.n2138 0.001
R10405 vss_1v2.n2392 vss_1v2.n2138 0.001
R10406 vss_1v2.n2222 vss_1v2.n2061 0.001
R10407 vss_1v2.n2393 vss_1v2.n2139 0.001
R10408 vss_1v2.n2256 vss_1v2.n2140 0.001
R10409 vss_1v2.n2394 vss_1v2.n2140 0.001
R10410 vss_1v2.n2257 vss_1v2.n2141 0.001
R10411 vss_1v2.n2395 vss_1v2.n2141 0.001
R10412 vss_1v2.n2258 vss_1v2.n2142 0.001
R10413 vss_1v2.n2396 vss_1v2.n2142 0.001
R10414 vss_1v2.n2259 vss_1v2.n2143 0.001
R10415 vss_1v2.n2397 vss_1v2.n2143 0.001
R10416 vss_1v2.n2260 vss_1v2.n2144 0.001
R10417 vss_1v2.n2398 vss_1v2.n2144 0.001
R10418 vss_1v2.n2400 vss_1v2.n2145 0.001
R10419 vss_1v2.n2399 vss_1v2.n2055 0.001
R10420 vss_1v2.n2326 vss_1v2.n2055 0.001
R10421 vss_1v2.n2221 vss_1v2.n2054 0.001
R10422 vss_1v2.n2325 vss_1v2.n2054 0.001
R10423 vss_1v2.n2324 vss_1v2.n2053 0.001
R10424 vss_1v2.n2323 vss_1v2.n2147 0.001
R10425 vss_1v2.n2401 vss_1v2.n2147 0.001
R10426 vss_1v2.n2403 vss_1v2.n2148 0.001
R10427 vss_1v2.n2402 vss_1v2.n2052 0.001
R10428 vss_1v2.n2322 vss_1v2.n2052 0.001
R10429 vss_1v2.n2220 vss_1v2.n2051 0.001
R10430 vss_1v2.n2321 vss_1v2.n2051 0.001
R10431 vss_1v2.n2319 vss_1v2.n2150 0.001
R10432 vss_1v2.n3902 vss_1v2.n2151 0.001
R10433 vss_1v2.n3902 vss_1v2.n2404 0.001
R10434 vss_1v2.n2261 vss_1v2.n2152 0.001
R10435 vss_1v2.n2405 vss_1v2.n2152 0.001
R10436 vss_1v2.n2407 vss_1v2.n2153 0.001
R10437 vss_1v2.n2406 vss_1v2.n2049 0.001
R10438 vss_1v2.n2318 vss_1v2.n2049 0.001
R10439 vss_1v2.n2219 vss_1v2.n2048 0.001
R10440 vss_1v2.n2317 vss_1v2.n2048 0.001
R10441 vss_1v2.n2218 vss_1v2.n2047 0.001
R10442 vss_1v2.n2316 vss_1v2.n2047 0.001
R10443 vss_1v2.n2217 vss_1v2.n2046 0.001
R10444 vss_1v2.n2315 vss_1v2.n2046 0.001
R10445 vss_1v2.n2216 vss_1v2.n2045 0.001
R10446 vss_1v2.n2314 vss_1v2.n2045 0.001
R10447 vss_1v2.n2313 vss_1v2.n2044 0.001
R10448 vss_1v2.n2312 vss_1v2.n2158 0.001
R10449 vss_1v2.n2408 vss_1v2.n2158 0.001
R10450 vss_1v2.n2262 vss_1v2.n2159 0.001
R10451 vss_1v2.n2409 vss_1v2.n2159 0.001
R10452 vss_1v2.n2263 vss_1v2.n2160 0.001
R10453 vss_1v2.n2410 vss_1v2.n2160 0.001
R10454 vss_1v2.n2264 vss_1v2.n2161 0.001
R10455 vss_1v2.n2411 vss_1v2.n2161 0.001
R10456 vss_1v2.n2413 vss_1v2.n2162 0.001
R10457 vss_1v2.n2412 vss_1v2.n2040 0.001
R10458 vss_1v2.n2311 vss_1v2.n2040 0.001
R10459 vss_1v2.n2215 vss_1v2.n2039 0.001
R10460 vss_1v2.n2310 vss_1v2.n2039 0.001
R10461 vss_1v2.n2214 vss_1v2.n2038 0.001
R10462 vss_1v2.n2309 vss_1v2.n2038 0.001
R10463 vss_1v2.n2213 vss_1v2.n2037 0.001
R10464 vss_1v2.n2308 vss_1v2.n2037 0.001
R10465 vss_1v2.n2212 vss_1v2.n2036 0.001
R10466 vss_1v2.n2307 vss_1v2.n2036 0.001
R10467 vss_1v2.n2306 vss_1v2.n2035 0.001
R10468 vss_1v2.n2305 vss_1v2.n2167 0.001
R10469 vss_1v2.n2414 vss_1v2.n2167 0.001
R10470 vss_1v2.n2265 vss_1v2.n2168 0.001
R10471 vss_1v2.n2415 vss_1v2.n2168 0.001
R10472 vss_1v2.n2266 vss_1v2.n2169 0.001
R10473 vss_1v2.n2416 vss_1v2.n2169 0.001
R10474 vss_1v2.n2267 vss_1v2.n2170 0.001
R10475 vss_1v2.n2417 vss_1v2.n2170 0.001
R10476 vss_1v2.n2419 vss_1v2.n2171 0.001
R10477 vss_1v2.n2418 vss_1v2.n2031 0.001
R10478 vss_1v2.n2304 vss_1v2.n2031 0.001
R10479 vss_1v2.n2211 vss_1v2.n2030 0.001
R10480 vss_1v2.n2303 vss_1v2.n2030 0.001
R10481 vss_1v2.n2210 vss_1v2.n2029 0.001
R10482 vss_1v2.n2302 vss_1v2.n2029 0.001
R10483 vss_1v2.n2209 vss_1v2.n2028 0.001
R10484 vss_1v2.n2301 vss_1v2.n2028 0.001
R10485 vss_1v2.n2208 vss_1v2.n2027 0.001
R10486 vss_1v2.n2300 vss_1v2.n2027 0.001
R10487 vss_1v2.n2299 vss_1v2.n2026 0.001
R10488 vss_1v2.n2298 vss_1v2.n2176 0.001
R10489 vss_1v2.n2420 vss_1v2.n2176 0.001
R10490 vss_1v2.n2268 vss_1v2.n2177 0.001
R10491 vss_1v2.n2421 vss_1v2.n2177 0.001
R10492 vss_1v2.n2269 vss_1v2.n2178 0.001
R10493 vss_1v2.n2422 vss_1v2.n2178 0.001
R10494 vss_1v2.n2270 vss_1v2.n2179 0.001
R10495 vss_1v2.n2423 vss_1v2.n2179 0.001
R10496 vss_1v2.n2271 vss_1v2.n2180 0.001
R10497 vss_1v2.n2424 vss_1v2.n2180 0.001
R10498 vss_1v2.n2426 vss_1v2.n2181 0.001
R10499 vss_1v2.n2425 vss_1v2.n2021 0.001
R10500 vss_1v2.n2297 vss_1v2.n2021 0.001
R10501 vss_1v2.n2207 vss_1v2.n2020 0.001
R10502 vss_1v2.n2296 vss_1v2.n2020 0.001
R10503 vss_1v2.n2206 vss_1v2.n2019 0.001
R10504 vss_1v2.n2295 vss_1v2.n2019 0.001
R10505 vss_1v2.n2205 vss_1v2.n2018 0.001
R10506 vss_1v2.n2294 vss_1v2.n2018 0.001
R10507 vss_1v2.n2293 vss_1v2.n2017 0.001
R10508 vss_1v2.n2292 vss_1v2.n2185 0.001
R10509 vss_1v2.n2427 vss_1v2.n2185 0.001
R10510 vss_1v2.n2272 vss_1v2.n2186 0.001
R10511 vss_1v2.n2428 vss_1v2.n2186 0.001
R10512 vss_1v2.n2273 vss_1v2.n2187 0.001
R10513 vss_1v2.n2429 vss_1v2.n2187 0.001
R10514 vss_1v2.n2274 vss_1v2.n2188 0.001
R10515 vss_1v2.n2430 vss_1v2.n2188 0.001
R10516 vss_1v2.n2275 vss_1v2.n2189 0.001
R10517 vss_1v2.n2431 vss_1v2.n2189 0.001
R10518 vss_1v2.n3999 vss_1v2.n2190 0.001
R10519 vss_1v2.n2432 vss_1v2.n2012 0.001
R10520 vss_1v2.n2291 vss_1v2.n2012 0.001
R10521 vss_1v2.n2204 vss_1v2.n2011 0.001
R10522 vss_1v2.n2290 vss_1v2.n2011 0.001
R10523 vss_1v2.n2203 vss_1v2.n2010 0.001
R10524 vss_1v2.n2289 vss_1v2.n2010 0.001
R10525 vss_1v2.n2202 vss_1v2.n2009 0.001
R10526 vss_1v2.n2288 vss_1v2.n2009 0.001
R10527 vss_1v2.n2201 vss_1v2.n2008 0.001
R10528 vss_1v2.n2287 vss_1v2.n2008 0.001
R10529 vss_1v2.n4004 vss_1v2.n2007 0.001
R10530 vss_1v2.n2284 vss_1v2.n2195 0.001
R10531 vss_1v2.n4000 vss_1v2.n2195 0.001
R10532 vss_1v2.n2276 vss_1v2.n2196 0.001
R10533 vss_1v2.n4001 vss_1v2.n2196 0.001
R10534 vss_1v2.n2277 vss_1v2.n2197 0.001
R10535 vss_1v2.n4002 vss_1v2.n2197 0.001
R10536 vss_1v2.n2278 vss_1v2.n2198 0.001
R10537 vss_1v2.n2280 vss_1v2.n2198 0.001
R10538 vss_1v2.n4015 vss_1v2.n2199 0.001
R10539 vss_1v2.n2200 vss_1v2.n2003 0.001
R10540 vss_1v2.n2003 vss_1v2.n1898 0.001
R10541 vss_1v2.n2978 vss_1v2.n308 0.0015
R10542 vss_1v2.n309 vss_1v2.n308 0.0015
R10543 vss_1v2.n3341 vss_1v2.n307 0.0015
R10544 vss_1v2.n3332 vss_1v2.n305 0.0015
R10545 vss_1v2.n3332 vss_1v2.n303 0.0015
R10546 vss_1v2.n260 vss_1v2.n219 0.0015
R10547 vss_1v2.n72 vss_1v2.n206 8.50175
R10548 vss_1v2.n72 vss_1v2.n71 0.893666
R10549 vss_1v2.t46 vss_1v2.n14 0.793969
R10550 vss_1v2.n3 vss_1v2.n260 2.91529
R10551 vss_1v2 vss_1v2.n0 0.0005
R10552 ota_cmfb_top_0.dynamic_pcell$5_0.DRN_NET_E_GATE_CDEFGH.n64 ota_cmfb_top_0.dynamic_pcell$5_0.DRN_NET_E_GATE_CDEFGH.t4 53.0574
R10553 ota_cmfb_top_0.dynamic_pcell$5_0.DRN_NET_E_GATE_CDEFGH ota_cmfb_top_0.dynamic_pcell$5_0.DRN_NET_E_GATE_CDEFGH.t3 26.2926
R10554 ota_cmfb_top_0.dynamic_pcell$5_0.DRN_NET_E_GATE_CDEFGH ota_cmfb_top_0.dynamic_pcell$5_0.DRN_NET_E_GATE_CDEFGH.t1 26.1914
R10555 ota_cmfb_top_0.dynamic_pcell$5_0.DRN_NET_E_GATE_CDEFGH.n68 ota_cmfb_top_0.dynamic_pcell$5_0.DRN_NET_E_GATE_CDEFGH.n4 15.3149
R10556 ota_cmfb_top_0.dynamic_pcell$5_0.DRN_NET_E_GATE_CDEFGH.n69 ota_cmfb_top_0.dynamic_pcell$5_0.DRN_NET_E_GATE_CDEFGH.n54 15.3149
R10557 ota_cmfb_top_0.dynamic_pcell$5_0.DRN_NET_E_GATE_CDEFGH.n70 ota_cmfb_top_0.dynamic_pcell$5_0.DRN_NET_E_GATE_CDEFGH.n7 15.3149
R10558 ota_cmfb_top_0.dynamic_pcell$5_0.DRN_NET_E_GATE_CDEFGH.n65 ota_cmfb_top_0.dynamic_pcell$5_0.DRN_NET_E_GATE_CDEFGH.n12 15.3149
R10559 ota_cmfb_top_0.dynamic_pcell$5_0.DRN_NET_E_GATE_CDEFGH.n64 ota_cmfb_top_0.dynamic_pcell$5_0.DRN_NET_E_GATE_CDEFGH.n56 15.3149
R10560 ota_cmfb_top_0.dynamic_pcell$5_0.DRN_NET_E_GATE_CDEFGH ota_cmfb_top_0.dynamic_pcell$5_0.DRN_NET_E_GATE_CDEFGH.n15 2.94552
R10561 ota_cmfb_top_0.dynamic_pcell$5_0.DRN_NET_E_GATE_CDEFGH.n17 ota_cmfb_top_0.dynamic_pcell$5_0.DRN_NET_E_GATE_CDEFGH 2.94552
R10562 ota_cmfb_top_0.dynamic_pcell$5_0.DRN_NET_E_GATE_CDEFGH.t2 ota_cmfb_top_0.dynamic_pcell$5_0.DRN_NET_E_GATE_CDEFGH 1.64028
R10563 ota_cmfb_top_0.dynamic_pcell$5_0.DRN_NET_E_GATE_CDEFGH ota_cmfb_top_0.dynamic_pcell$5_0.DRN_NET_E_GATE_CDEFGH.n24 2.94552
R10564 ota_cmfb_top_0.dynamic_pcell$5_0.DRN_NET_E_GATE_CDEFGH ota_cmfb_top_0.dynamic_pcell$5_0.DRN_NET_E_GATE_CDEFGH.n26 2.94552
R10565 ota_cmfb_top_0.dynamic_pcell$5_0.DRN_NET_E_GATE_CDEFGH ota_cmfb_top_0.dynamic_pcell$5_0.DRN_NET_E_GATE_CDEFGH.n0 1.96988
R10566 ota_cmfb_top_0.dynamic_pcell$5_0.DRN_NET_E_GATE_CDEFGH ota_cmfb_top_0.dynamic_pcell$5_0.DRN_NET_E_GATE_CDEFGH.n1 1.96988
R10567 ota_cmfb_top_0.dynamic_pcell$5_0.DRN_NET_E_GATE_CDEFGH.n28 ota_cmfb_top_0.dynamic_pcell$5_0.DRN_NET_E_GATE_CDEFGH 1.93287
R10568 ota_cmfb_top_0.dynamic_pcell$5_0.DRN_NET_E_GATE_CDEFGH.t0 ota_cmfb_top_0.dynamic_pcell$5_0.DRN_NET_E_GATE_CDEFGH.n28 0.745706
R10569 ota_cmfb_top_0.dynamic_pcell$5_0.DRN_NET_E_GATE_CDEFGH ota_cmfb_top_0.dynamic_pcell$5_0.DRN_NET_E_GATE_CDEFGH.n29 2.94552
R10570 ota_cmfb_top_0.dynamic_pcell$5_0.DRN_NET_E_GATE_CDEFGH ota_cmfb_top_0.dynamic_pcell$5_0.DRN_NET_E_GATE_CDEFGH.n31 2.94552
R10571 ota_cmfb_top_0.dynamic_pcell$5_0.DRN_NET_E_GATE_CDEFGH.n68 ota_cmfb_top_0.dynamic_pcell$5_0.DRN_NET_E_GATE_CDEFGH.t5 13.9527
R10572 ota_cmfb_top_0.dynamic_pcell$5_0.DRN_NET_E_GATE_CDEFGH.n67 ota_cmfb_top_0.dynamic_pcell$5_0.DRN_NET_E_GATE_CDEFGH.n66 12.8065
R10573 ota_cmfb_top_0.dynamic_pcell$5_0.DRN_NET_E_GATE_CDEFGH.n8 ota_cmfb_top_0.dynamic_pcell$5_0.DRN_NET_E_GATE_CDEFGH 11.3693
R10574 ota_cmfb_top_0.dynamic_pcell$5_0.DRN_NET_E_GATE_CDEFGH.n66 ota_cmfb_top_0.dynamic_pcell$5_0.DRN_NET_E_GATE_CDEFGH 9.20684
R10575 ota_cmfb_top_0.dynamic_pcell$5_0.DRN_NET_E_GATE_CDEFGH.n37 ota_cmfb_top_0.dynamic_pcell$5_0.DRN_NET_E_GATE_CDEFGH.t9 1.64845
R10576 ota_cmfb_top_0.dynamic_pcell$5_0.DRN_NET_E_GATE_CDEFGH.n44 ota_cmfb_top_0.dynamic_pcell$5_0.DRN_NET_E_GATE_CDEFGH 1.644
R10577 ota_cmfb_top_0.dynamic_pcell$5_0.DRN_NET_E_GATE_CDEFGH.n6 ota_cmfb_top_0.dynamic_pcell$5_0.DRN_NET_E_GATE_CDEFGH 2.12472
R10578 ota_cmfb_top_0.dynamic_pcell$5_0.DRN_NET_E_GATE_CDEFGH.n11 ota_cmfb_top_0.dynamic_pcell$5_0.DRN_NET_E_GATE_CDEFGH 2.12472
R10579 ota_cmfb_top_0.dynamic_pcell$5_0.DRN_NET_E_GATE_CDEFGH.n47 ota_cmfb_top_0.dynamic_pcell$5_0.DRN_NET_E_GATE_CDEFGH.t10 1.64392
R10580 ota_cmfb_top_0.dynamic_pcell$5_0.DRN_NET_E_GATE_CDEFGH.n14 ota_cmfb_top_0.dynamic_pcell$5_0.DRN_NET_E_GATE_CDEFGH 2.26239
R10581 ota_cmfb_top_0.dynamic_pcell$5_0.DRN_NET_E_GATE_CDEFGH.n20 ota_cmfb_top_0.dynamic_pcell$5_0.DRN_NET_E_GATE_CDEFGH.t6 1.64205
R10582 ota_cmfb_top_0.dynamic_pcell$5_0.DRN_NET_E_GATE_CDEFGH.n55 ota_cmfb_top_0.dynamic_pcell$5_0.DRN_NET_E_GATE_CDEFGH 2.12471
R10583 ota_cmfb_top_0.dynamic_pcell$5_0.DRN_NET_E_GATE_CDEFGH.n34 ota_cmfb_top_0.dynamic_pcell$5_0.DRN_NET_E_GATE_CDEFGH 1.64212
R10584 ota_cmfb_top_0.dynamic_pcell$5_0.DRN_NET_E_GATE_CDEFGH.n57 ota_cmfb_top_0.dynamic_pcell$5_0.DRN_NET_E_GATE_CDEFGH 2.12471
R10585 ota_cmfb_top_0.dynamic_pcell$5_0.DRN_NET_E_GATE_CDEFGH ota_cmfb_top_0.dynamic_pcell$5_0.DRN_NET_E_GATE_CDEFGH.n4 2.90958
R10586 ota_cmfb_top_0.dynamic_pcell$5_0.DRN_NET_E_GATE_CDEFGH.n5 ota_cmfb_top_0.dynamic_pcell$5_0.DRN_NET_E_GATE_CDEFGH.n6 3.272
R10587 ota_cmfb_top_0.dynamic_pcell$5_0.DRN_NET_E_GATE_CDEFGH.n5 ota_cmfb_top_0.dynamic_pcell$5_0.DRN_NET_E_GATE_CDEFGH 0.456156
R10588 ota_cmfb_top_0.dynamic_pcell$5_0.DRN_NET_E_GATE_CDEFGH ota_cmfb_top_0.dynamic_pcell$5_0.DRN_NET_E_GATE_CDEFGH.n43 2.12467
R10589 ota_cmfb_top_0.dynamic_pcell$5_0.DRN_NET_E_GATE_CDEFGH.n59 ota_cmfb_top_0.dynamic_pcell$5_0.DRN_NET_E_GATE_CDEFGH 2.90958
R10590 ota_cmfb_top_0.dynamic_pcell$5_0.DRN_NET_E_GATE_CDEFGH ota_cmfb_top_0.dynamic_pcell$5_0.DRN_NET_E_GATE_CDEFGH.n15 2.33345
R10591 ota_cmfb_top_0.dynamic_pcell$5_0.DRN_NET_E_GATE_CDEFGH.n16 ota_cmfb_top_0.dynamic_pcell$5_0.DRN_NET_E_GATE_CDEFGH.n15 0.876363
R10592 ota_cmfb_top_0.dynamic_pcell$5_0.DRN_NET_E_GATE_CDEFGH ota_cmfb_top_0.dynamic_pcell$5_0.DRN_NET_E_GATE_CDEFGH.n16 1.00975
R10593 ota_cmfb_top_0.dynamic_pcell$5_0.DRN_NET_E_GATE_CDEFGH.n17 ota_cmfb_top_0.dynamic_pcell$5_0.DRN_NET_E_GATE_CDEFGH 2.33345
R10594 ota_cmfb_top_0.dynamic_pcell$5_0.DRN_NET_E_GATE_CDEFGH.n18 ota_cmfb_top_0.dynamic_pcell$5_0.DRN_NET_E_GATE_CDEFGH.n17 0.876363
R10595 ota_cmfb_top_0.dynamic_pcell$5_0.DRN_NET_E_GATE_CDEFGH.n18 ota_cmfb_top_0.dynamic_pcell$5_0.DRN_NET_E_GATE_CDEFGH 1.00975
R10596 ota_cmfb_top_0.dynamic_pcell$5_0.DRN_NET_E_GATE_CDEFGH.n2 ota_cmfb_top_0.dynamic_pcell$5_0.DRN_NET_E_GATE_CDEFGH 1.6542
R10597 ota_cmfb_top_0.dynamic_pcell$5_0.DRN_NET_E_GATE_CDEFGH ota_cmfb_top_0.dynamic_pcell$5_0.DRN_NET_E_GATE_CDEFGH.n54 2.90958
R10598 ota_cmfb_top_0.dynamic_pcell$5_0.DRN_NET_E_GATE_CDEFGH ota_cmfb_top_0.dynamic_pcell$5_0.DRN_NET_E_GATE_CDEFGH.n22 2.12467
R10599 ota_cmfb_top_0.dynamic_pcell$5_0.DRN_NET_E_GATE_CDEFGH.n62 ota_cmfb_top_0.dynamic_pcell$5_0.DRN_NET_E_GATE_CDEFGH 3.12758
R10600 ota_cmfb_top_0.dynamic_pcell$5_0.DRN_NET_E_GATE_CDEFGH.n19 ota_cmfb_top_0.dynamic_pcell$5_0.DRN_NET_E_GATE_CDEFGH 2.12467
R10601 ota_cmfb_top_0.dynamic_pcell$5_0.DRN_NET_E_GATE_CDEFGH.n63 ota_cmfb_top_0.dynamic_pcell$5_0.DRN_NET_E_GATE_CDEFGH 3.12758
R10602 ota_cmfb_top_0.dynamic_pcell$5_0.DRN_NET_E_GATE_CDEFGH ota_cmfb_top_0.dynamic_pcell$5_0.DRN_NET_E_GATE_CDEFGH.n20 0.0422694
R10603 ota_cmfb_top_0.dynamic_pcell$5_0.DRN_NET_E_GATE_CDEFGH.t7 ota_cmfb_top_0.dynamic_pcell$5_0.DRN_NET_E_GATE_CDEFGH 1.68104
R10604 ota_cmfb_top_0.dynamic_pcell$5_0.DRN_NET_E_GATE_CDEFGH ota_cmfb_top_0.dynamic_pcell$5_0.DRN_NET_E_GATE_CDEFGH.n7 2.90958
R10605 ota_cmfb_top_0.dynamic_pcell$5_0.DRN_NET_E_GATE_CDEFGH.n11 ota_cmfb_top_0.dynamic_pcell$5_0.DRN_NET_E_GATE_CDEFGH.n10 3.272
R10606 ota_cmfb_top_0.dynamic_pcell$5_0.DRN_NET_E_GATE_CDEFGH.n10 ota_cmfb_top_0.dynamic_pcell$5_0.DRN_NET_E_GATE_CDEFGH 0.456156
R10607 ota_cmfb_top_0.dynamic_pcell$5_0.DRN_NET_E_GATE_CDEFGH.n10 ota_cmfb_top_0.dynamic_pcell$5_0.DRN_NET_E_GATE_CDEFGH.n9 4.00174
R10608 ota_cmfb_top_0.dynamic_pcell$5_0.DRN_NET_E_GATE_CDEFGH.n9 ota_cmfb_top_0.dynamic_pcell$5_0.DRN_NET_E_GATE_CDEFGH 0.456156
R10609 ota_cmfb_top_0.dynamic_pcell$5_0.DRN_NET_E_GATE_CDEFGH.n9 ota_cmfb_top_0.dynamic_pcell$5_0.DRN_NET_E_GATE_CDEFGH.n8 4.00174
R10610 ota_cmfb_top_0.dynamic_pcell$5_0.DRN_NET_E_GATE_CDEFGH.n8 ota_cmfb_top_0.dynamic_pcell$5_0.DRN_NET_E_GATE_CDEFGH 0.456156
R10611 ota_cmfb_top_0.dynamic_pcell$5_0.DRN_NET_E_GATE_CDEFGH ota_cmfb_top_0.dynamic_pcell$5_0.DRN_NET_E_GATE_CDEFGH.n24 2.33345
R10612 ota_cmfb_top_0.dynamic_pcell$5_0.DRN_NET_E_GATE_CDEFGH.n25 ota_cmfb_top_0.dynamic_pcell$5_0.DRN_NET_E_GATE_CDEFGH.n24 0.876363
R10613 ota_cmfb_top_0.dynamic_pcell$5_0.DRN_NET_E_GATE_CDEFGH ota_cmfb_top_0.dynamic_pcell$5_0.DRN_NET_E_GATE_CDEFGH.n25 1.00975
R10614 ota_cmfb_top_0.dynamic_pcell$5_0.DRN_NET_E_GATE_CDEFGH ota_cmfb_top_0.dynamic_pcell$5_0.DRN_NET_E_GATE_CDEFGH.n26 2.33345
R10615 ota_cmfb_top_0.dynamic_pcell$5_0.DRN_NET_E_GATE_CDEFGH.n27 ota_cmfb_top_0.dynamic_pcell$5_0.DRN_NET_E_GATE_CDEFGH.n26 0.876363
R10616 ota_cmfb_top_0.dynamic_pcell$5_0.DRN_NET_E_GATE_CDEFGH ota_cmfb_top_0.dynamic_pcell$5_0.DRN_NET_E_GATE_CDEFGH.n27 1.00975
R10617 ota_cmfb_top_0.dynamic_pcell$5_0.DRN_NET_E_GATE_CDEFGH ota_cmfb_top_0.dynamic_pcell$5_0.DRN_NET_E_GATE_CDEFGH.n41 2.12467
R10618 ota_cmfb_top_0.dynamic_pcell$5_0.DRN_NET_E_GATE_CDEFGH.n49 ota_cmfb_top_0.dynamic_pcell$5_0.DRN_NET_E_GATE_CDEFGH 2.90958
R10619 ota_cmfb_top_0.dynamic_pcell$5_0.DRN_NET_E_GATE_CDEFGH ota_cmfb_top_0.dynamic_pcell$5_0.DRN_NET_E_GATE_CDEFGH.n39 2.12467
R10620 ota_cmfb_top_0.dynamic_pcell$5_0.DRN_NET_E_GATE_CDEFGH.n50 ota_cmfb_top_0.dynamic_pcell$5_0.DRN_NET_E_GATE_CDEFGH 2.90958
R10621 ota_cmfb_top_0.dynamic_pcell$5_0.DRN_NET_E_GATE_CDEFGH.n36 ota_cmfb_top_0.dynamic_pcell$5_0.DRN_NET_E_GATE_CDEFGH 2.12467
R10622 ota_cmfb_top_0.dynamic_pcell$5_0.DRN_NET_E_GATE_CDEFGH.n51 ota_cmfb_top_0.dynamic_pcell$5_0.DRN_NET_E_GATE_CDEFGH 2.90958
R10623 ota_cmfb_top_0.dynamic_pcell$5_0.DRN_NET_E_GATE_CDEFGH ota_cmfb_top_0.dynamic_pcell$5_0.DRN_NET_E_GATE_CDEFGH.n37 0.0867705
R10624 ota_cmfb_top_0.dynamic_pcell$5_0.DRN_NET_E_GATE_CDEFGH ota_cmfb_top_0.dynamic_pcell$5_0.DRN_NET_E_GATE_CDEFGH.n0 0.504353
R10625 ota_cmfb_top_0.dynamic_pcell$5_0.DRN_NET_E_GATE_CDEFGH ota_cmfb_top_0.dynamic_pcell$5_0.DRN_NET_E_GATE_CDEFGH.n1 0.504353
R10626 ota_cmfb_top_0.dynamic_pcell$5_0.DRN_NET_E_GATE_CDEFGH ota_cmfb_top_0.dynamic_pcell$5_0.DRN_NET_E_GATE_CDEFGH.n28 1.65534
R10627 ota_cmfb_top_0.dynamic_pcell$5_0.DRN_NET_E_GATE_CDEFGH ota_cmfb_top_0.dynamic_pcell$5_0.DRN_NET_E_GATE_CDEFGH.n12 2.90958
R10628 ota_cmfb_top_0.dynamic_pcell$5_0.DRN_NET_E_GATE_CDEFGH.n14 ota_cmfb_top_0.dynamic_pcell$5_0.DRN_NET_E_GATE_CDEFGH.n13 3.272
R10629 ota_cmfb_top_0.dynamic_pcell$5_0.DRN_NET_E_GATE_CDEFGH.n13 ota_cmfb_top_0.dynamic_pcell$5_0.DRN_NET_E_GATE_CDEFGH 0.456156
R10630 ota_cmfb_top_0.dynamic_pcell$5_0.DRN_NET_E_GATE_CDEFGH.n46 ota_cmfb_top_0.dynamic_pcell$5_0.DRN_NET_E_GATE_CDEFGH 2.12467
R10631 ota_cmfb_top_0.dynamic_pcell$5_0.DRN_NET_E_GATE_CDEFGH.n58 ota_cmfb_top_0.dynamic_pcell$5_0.DRN_NET_E_GATE_CDEFGH 2.90958
R10632 ota_cmfb_top_0.dynamic_pcell$5_0.DRN_NET_E_GATE_CDEFGH ota_cmfb_top_0.dynamic_pcell$5_0.DRN_NET_E_GATE_CDEFGH.n47 0.0565494
R10633 ota_cmfb_top_0.dynamic_pcell$5_0.DRN_NET_E_GATE_CDEFGH ota_cmfb_top_0.dynamic_pcell$5_0.DRN_NET_E_GATE_CDEFGH.n29 2.33345
R10634 ota_cmfb_top_0.dynamic_pcell$5_0.DRN_NET_E_GATE_CDEFGH.n30 ota_cmfb_top_0.dynamic_pcell$5_0.DRN_NET_E_GATE_CDEFGH.n29 0.876363
R10635 ota_cmfb_top_0.dynamic_pcell$5_0.DRN_NET_E_GATE_CDEFGH ota_cmfb_top_0.dynamic_pcell$5_0.DRN_NET_E_GATE_CDEFGH.n30 1.00975
R10636 ota_cmfb_top_0.dynamic_pcell$5_0.DRN_NET_E_GATE_CDEFGH ota_cmfb_top_0.dynamic_pcell$5_0.DRN_NET_E_GATE_CDEFGH.n31 2.33345
R10637 ota_cmfb_top_0.dynamic_pcell$5_0.DRN_NET_E_GATE_CDEFGH.n32 ota_cmfb_top_0.dynamic_pcell$5_0.DRN_NET_E_GATE_CDEFGH.n31 0.876363
R10638 ota_cmfb_top_0.dynamic_pcell$5_0.DRN_NET_E_GATE_CDEFGH ota_cmfb_top_0.dynamic_pcell$5_0.DRN_NET_E_GATE_CDEFGH.n32 1.00975
R10639 ota_cmfb_top_0.dynamic_pcell$5_0.DRN_NET_E_GATE_CDEFGH ota_cmfb_top_0.dynamic_pcell$5_0.DRN_NET_E_GATE_CDEFGH.n56 2.90958
R10640 ota_cmfb_top_0.dynamic_pcell$5_0.DRN_NET_E_GATE_CDEFGH.n52 ota_cmfb_top_0.dynamic_pcell$5_0.DRN_NET_E_GATE_CDEFGH 2.12467
R10641 ota_cmfb_top_0.dynamic_pcell$5_0.DRN_NET_E_GATE_CDEFGH.n60 ota_cmfb_top_0.dynamic_pcell$5_0.DRN_NET_E_GATE_CDEFGH 3.12758
R10642 ota_cmfb_top_0.dynamic_pcell$5_0.DRN_NET_E_GATE_CDEFGH ota_cmfb_top_0.dynamic_pcell$5_0.DRN_NET_E_GATE_CDEFGH.n33 2.12467
R10643 ota_cmfb_top_0.dynamic_pcell$5_0.DRN_NET_E_GATE_CDEFGH.n61 ota_cmfb_top_0.dynamic_pcell$5_0.DRN_NET_E_GATE_CDEFGH 3.12758
R10644 ota_cmfb_top_0.dynamic_pcell$5_0.DRN_NET_E_GATE_CDEFGH ota_cmfb_top_0.dynamic_pcell$5_0.DRN_NET_E_GATE_CDEFGH.n16 1.36536
R10645 ota_cmfb_top_0.dynamic_pcell$5_0.DRN_NET_E_GATE_CDEFGH.n18 ota_cmfb_top_0.dynamic_pcell$5_0.DRN_NET_E_GATE_CDEFGH 1.36536
R10646 ota_cmfb_top_0.dynamic_pcell$5_0.DRN_NET_E_GATE_CDEFGH.n2 ota_cmfb_top_0.dynamic_pcell$5_0.DRN_NET_E_GATE_CDEFGH 5.22571
R10647 ota_cmfb_top_0.dynamic_pcell$5_0.DRN_NET_E_GATE_CDEFGH.n2 ota_cmfb_top_0.dynamic_pcell$5_0.DRN_NET_E_GATE_CDEFGH.n3 0.897298
R10648 ota_cmfb_top_0.dynamic_pcell$5_0.DRN_NET_E_GATE_CDEFGH ota_cmfb_top_0.dynamic_pcell$5_0.DRN_NET_E_GATE_CDEFGH.n25 1.36536
R10649 ota_cmfb_top_0.dynamic_pcell$5_0.DRN_NET_E_GATE_CDEFGH ota_cmfb_top_0.dynamic_pcell$5_0.DRN_NET_E_GATE_CDEFGH.n27 1.36536
R10650 ota_cmfb_top_0.dynamic_pcell$5_0.DRN_NET_E_GATE_CDEFGH ota_cmfb_top_0.dynamic_pcell$5_0.DRN_NET_E_GATE_CDEFGH.n0 2.59534
R10651 ota_cmfb_top_0.dynamic_pcell$5_0.DRN_NET_E_GATE_CDEFGH ota_cmfb_top_0.dynamic_pcell$5_0.DRN_NET_E_GATE_CDEFGH.n1 2.59534
R10652 ota_cmfb_top_0.dynamic_pcell$5_0.DRN_NET_E_GATE_CDEFGH ota_cmfb_top_0.dynamic_pcell$5_0.DRN_NET_E_GATE_CDEFGH.n30 1.36536
R10653 ota_cmfb_top_0.dynamic_pcell$5_0.DRN_NET_E_GATE_CDEFGH ota_cmfb_top_0.dynamic_pcell$5_0.DRN_NET_E_GATE_CDEFGH.n32 1.36536
R10654 ota_cmfb_top_0.dynamic_pcell$5_0.DRN_NET_E_GATE_CDEFGH.t8 ota_cmfb_top_0.dynamic_pcell$5_0.DRN_NET_E_GATE_CDEFGH 1.72639
R10655 ota_cmfb_top_0.dynamic_pcell$5_0.DRN_NET_E_GATE_CDEFGH.n70 ota_cmfb_top_0.dynamic_pcell$5_0.DRN_NET_E_GATE_CDEFGH.n69 2.15999
R10656 ota_cmfb_top_0.dynamic_pcell$5_0.DRN_NET_E_GATE_CDEFGH.n65 ota_cmfb_top_0.dynamic_pcell$5_0.DRN_NET_E_GATE_CDEFGH.n64 1.75519
R10657 ota_cmfb_top_0.dynamic_pcell$5_0.DRN_NET_E_GATE_CDEFGH.n67 ota_cmfb_top_0.dynamic_pcell$5_0.DRN_NET_E_GATE_CDEFGH.n65 1.75519
R10658 ota_cmfb_top_0.dynamic_pcell$5_0.DRN_NET_E_GATE_CDEFGH.n69 ota_cmfb_top_0.dynamic_pcell$5_0.DRN_NET_E_GATE_CDEFGH.n68 1.75519
R10659 ota_cmfb_top_0.dynamic_pcell$5_0.DRN_NET_E_GATE_CDEFGH.n3 ota_cmfb_top_0.dynamic_pcell$5_0.DRN_NET_E_GATE_CDEFGH 1.07639
R10660 ota_cmfb_top_0.dynamic_pcell$5_0.DRN_NET_E_GATE_CDEFGH ota_cmfb_top_0.dynamic_pcell$5_0.DRN_NET_E_GATE_CDEFGH.n67 1.28264
R10661 ota_cmfb_top_0.dynamic_pcell$5_0.DRN_NET_E_GATE_CDEFGH.n5 ota_cmfb_top_0.dynamic_pcell$5_0.DRN_NET_E_GATE_CDEFGH 2.06179
R10662 ota_cmfb_top_0.dynamic_pcell$5_0.DRN_NET_E_GATE_CDEFGH.n23 ota_cmfb_top_0.dynamic_pcell$5_0.DRN_NET_E_GATE_CDEFGH 1.52029
R10663 ota_cmfb_top_0.dynamic_pcell$5_0.DRN_NET_E_GATE_CDEFGH.n13 ota_cmfb_top_0.dynamic_pcell$5_0.DRN_NET_E_GATE_CDEFGH 2.06179
R10664 ota_cmfb_top_0.dynamic_pcell$5_0.DRN_NET_E_GATE_CDEFGH.n53 ota_cmfb_top_0.dynamic_pcell$5_0.DRN_NET_E_GATE_CDEFGH 1.52029
R10665 ota_cmfb_top_0.dynamic_pcell$5_0.DRN_NET_E_GATE_CDEFGH ota_cmfb_top_0.dynamic_pcell$5_0.DRN_NET_E_GATE_CDEFGH.n70 0.877845
R10666 ota_cmfb_top_0.dynamic_pcell$5_0.DRN_NET_E_GATE_CDEFGH.n34 ota_cmfb_top_0.dynamic_pcell$5_0.DRN_NET_E_GATE_CDEFGH 0.0422836
R10667 ota_cmfb_top_0.dynamic_pcell$5_0.DRN_NET_E_GATE_CDEFGH.n44 ota_cmfb_top_0.dynamic_pcell$5_0.DRN_NET_E_GATE_CDEFGH 0.0565682
R10668 ota_cmfb_top_0.dynamic_pcell$5_0.DRN_NET_E_GATE_CDEFGH.n6 ota_cmfb_top_0.dynamic_pcell$5_0.DRN_NET_E_GATE_CDEFGH.n4 0.725559
R10669 ota_cmfb_top_0.dynamic_pcell$5_0.DRN_NET_E_GATE_CDEFGH ota_cmfb_top_0.dynamic_pcell$5_0.DRN_NET_E_GATE_CDEFGH.n59 1.23727
R10670 ota_cmfb_top_0.dynamic_pcell$5_0.DRN_NET_E_GATE_CDEFGH.n43 ota_cmfb_top_0.dynamic_pcell$5_0.DRN_NET_E_GATE_CDEFGH.n59 0.725565
R10671 ota_cmfb_top_0.dynamic_pcell$5_0.DRN_NET_E_GATE_CDEFGH.n43 ota_cmfb_top_0.dynamic_pcell$5_0.DRN_NET_E_GATE_CDEFGH.n45 1.00864
R10672 ota_cmfb_top_0.dynamic_pcell$5_0.DRN_NET_E_GATE_CDEFGH.n45 ota_cmfb_top_0.dynamic_pcell$5_0.DRN_NET_E_GATE_CDEFGH.n44 4.21695
R10673 ota_cmfb_top_0.dynamic_pcell$5_0.DRN_NET_E_GATE_CDEFGH.n55 ota_cmfb_top_0.dynamic_pcell$5_0.DRN_NET_E_GATE_CDEFGH.n54 0.725561
R10674 ota_cmfb_top_0.dynamic_pcell$5_0.DRN_NET_E_GATE_CDEFGH.n55 ota_cmfb_top_0.dynamic_pcell$5_0.DRN_NET_E_GATE_CDEFGH.n62 2.56882
R10675 ota_cmfb_top_0.dynamic_pcell$5_0.DRN_NET_E_GATE_CDEFGH.n22 ota_cmfb_top_0.dynamic_pcell$5_0.DRN_NET_E_GATE_CDEFGH.n62 0.725565
R10676 ota_cmfb_top_0.dynamic_pcell$5_0.DRN_NET_E_GATE_CDEFGH.n22 ota_cmfb_top_0.dynamic_pcell$5_0.DRN_NET_E_GATE_CDEFGH.n23 1.00864
R10677 ota_cmfb_top_0.dynamic_pcell$5_0.DRN_NET_E_GATE_CDEFGH ota_cmfb_top_0.dynamic_pcell$5_0.DRN_NET_E_GATE_CDEFGH.n63 1.23727
R10678 ota_cmfb_top_0.dynamic_pcell$5_0.DRN_NET_E_GATE_CDEFGH.n19 ota_cmfb_top_0.dynamic_pcell$5_0.DRN_NET_E_GATE_CDEFGH.n63 0.725565
R10679 ota_cmfb_top_0.dynamic_pcell$5_0.DRN_NET_E_GATE_CDEFGH.n19 ota_cmfb_top_0.dynamic_pcell$5_0.DRN_NET_E_GATE_CDEFGH.n21 1.00864
R10680 ota_cmfb_top_0.dynamic_pcell$5_0.DRN_NET_E_GATE_CDEFGH.n21 ota_cmfb_top_0.dynamic_pcell$5_0.DRN_NET_E_GATE_CDEFGH.n20 4.21108
R10681 ota_cmfb_top_0.dynamic_pcell$5_0.DRN_NET_E_GATE_CDEFGH.n11 ota_cmfb_top_0.dynamic_pcell$5_0.DRN_NET_E_GATE_CDEFGH.n7 0.725559
R10682 ota_cmfb_top_0.dynamic_pcell$5_0.DRN_NET_E_GATE_CDEFGH.n66 ota_cmfb_top_0.dynamic_pcell$5_0.DRN_NET_E_GATE_CDEFGH.n49 1.23727
R10683 ota_cmfb_top_0.dynamic_pcell$5_0.DRN_NET_E_GATE_CDEFGH.n41 ota_cmfb_top_0.dynamic_pcell$5_0.DRN_NET_E_GATE_CDEFGH.n49 0.725565
R10684 ota_cmfb_top_0.dynamic_pcell$5_0.DRN_NET_E_GATE_CDEFGH.n42 ota_cmfb_top_0.dynamic_pcell$5_0.DRN_NET_E_GATE_CDEFGH.n41 1.00864
R10685 ota_cmfb_top_0.dynamic_pcell$5_0.DRN_NET_E_GATE_CDEFGH.n42 ota_cmfb_top_0.dynamic_pcell$5_0.DRN_NET_E_GATE_CDEFGH.n50 2.75706
R10686 ota_cmfb_top_0.dynamic_pcell$5_0.DRN_NET_E_GATE_CDEFGH.n39 ota_cmfb_top_0.dynamic_pcell$5_0.DRN_NET_E_GATE_CDEFGH.n50 0.725565
R10687 ota_cmfb_top_0.dynamic_pcell$5_0.DRN_NET_E_GATE_CDEFGH.n39 ota_cmfb_top_0.dynamic_pcell$5_0.DRN_NET_E_GATE_CDEFGH.n40 1.00864
R10688 ota_cmfb_top_0.dynamic_pcell$5_0.DRN_NET_E_GATE_CDEFGH.n40 ota_cmfb_top_0.dynamic_pcell$5_0.DRN_NET_E_GATE_CDEFGH.n51 2.75706
R10689 ota_cmfb_top_0.dynamic_pcell$5_0.DRN_NET_E_GATE_CDEFGH.n36 ota_cmfb_top_0.dynamic_pcell$5_0.DRN_NET_E_GATE_CDEFGH.n51 0.725565
R10690 ota_cmfb_top_0.dynamic_pcell$5_0.DRN_NET_E_GATE_CDEFGH.n36 ota_cmfb_top_0.dynamic_pcell$5_0.DRN_NET_E_GATE_CDEFGH.n38 1.00864
R10691 ota_cmfb_top_0.dynamic_pcell$5_0.DRN_NET_E_GATE_CDEFGH.n38 ota_cmfb_top_0.dynamic_pcell$5_0.DRN_NET_E_GATE_CDEFGH.n37 4.22904
R10692 ota_cmfb_top_0.dynamic_pcell$5_0.DRN_NET_E_GATE_CDEFGH.n14 ota_cmfb_top_0.dynamic_pcell$5_0.DRN_NET_E_GATE_CDEFGH.n12 0.725559
R10693 ota_cmfb_top_0.dynamic_pcell$5_0.DRN_NET_E_GATE_CDEFGH ota_cmfb_top_0.dynamic_pcell$5_0.DRN_NET_E_GATE_CDEFGH.n58 1.23727
R10694 ota_cmfb_top_0.dynamic_pcell$5_0.DRN_NET_E_GATE_CDEFGH.n46 ota_cmfb_top_0.dynamic_pcell$5_0.DRN_NET_E_GATE_CDEFGH.n58 0.725565
R10695 ota_cmfb_top_0.dynamic_pcell$5_0.DRN_NET_E_GATE_CDEFGH.n46 ota_cmfb_top_0.dynamic_pcell$5_0.DRN_NET_E_GATE_CDEFGH.n48 1.00864
R10696 ota_cmfb_top_0.dynamic_pcell$5_0.DRN_NET_E_GATE_CDEFGH.n48 ota_cmfb_top_0.dynamic_pcell$5_0.DRN_NET_E_GATE_CDEFGH.n47 4.21697
R10697 ota_cmfb_top_0.dynamic_pcell$5_0.DRN_NET_E_GATE_CDEFGH.n57 ota_cmfb_top_0.dynamic_pcell$5_0.DRN_NET_E_GATE_CDEFGH.n56 0.725561
R10698 ota_cmfb_top_0.dynamic_pcell$5_0.DRN_NET_E_GATE_CDEFGH.n57 ota_cmfb_top_0.dynamic_pcell$5_0.DRN_NET_E_GATE_CDEFGH.n60 2.56882
R10699 ota_cmfb_top_0.dynamic_pcell$5_0.DRN_NET_E_GATE_CDEFGH.n52 ota_cmfb_top_0.dynamic_pcell$5_0.DRN_NET_E_GATE_CDEFGH.n60 0.725565
R10700 ota_cmfb_top_0.dynamic_pcell$5_0.DRN_NET_E_GATE_CDEFGH.n52 ota_cmfb_top_0.dynamic_pcell$5_0.DRN_NET_E_GATE_CDEFGH.n53 1.00864
R10701 ota_cmfb_top_0.dynamic_pcell$5_0.DRN_NET_E_GATE_CDEFGH ota_cmfb_top_0.dynamic_pcell$5_0.DRN_NET_E_GATE_CDEFGH.n61 1.23727
R10702 ota_cmfb_top_0.dynamic_pcell$5_0.DRN_NET_E_GATE_CDEFGH.n33 ota_cmfb_top_0.dynamic_pcell$5_0.DRN_NET_E_GATE_CDEFGH.n61 0.725565
R10703 ota_cmfb_top_0.dynamic_pcell$5_0.DRN_NET_E_GATE_CDEFGH.n33 ota_cmfb_top_0.dynamic_pcell$5_0.DRN_NET_E_GATE_CDEFGH.n35 1.00864
R10704 ota_cmfb_top_0.dynamic_pcell$5_0.DRN_NET_E_GATE_CDEFGH.n35 ota_cmfb_top_0.dynamic_pcell$5_0.DRN_NET_E_GATE_CDEFGH.n34 4.21106
R10705 ota_cmfb_top_0.dynamic_pcell$5_0.DRN_NET_E_GATE_CDEFGH.n42 ota_cmfb_top_0.dynamic_pcell$5_0.DRN_NET_E_GATE_CDEFGH 1.98124
R10706 ota_cmfb_top_0.dynamic_pcell$5_0.DRN_NET_E_GATE_CDEFGH.n40 ota_cmfb_top_0.dynamic_pcell$5_0.DRN_NET_E_GATE_CDEFGH 1.95065
R10707 ota_cmfb_top_0.dynamic_pcell$5_0.DRN_NET_E_GATE_CDEFGH.n38 ota_cmfb_top_0.dynamic_pcell$5_0.DRN_NET_E_GATE_CDEFGH 1.95065
R10708 ota_cmfb_top_0.dynamic_pcell$5_0.DRN_NET_E_GATE_CDEFGH.n45 ota_cmfb_top_0.dynamic_pcell$5_0.DRN_NET_E_GATE_CDEFGH 1.72976
R10709 ota_cmfb_top_0.dynamic_pcell$5_0.DRN_NET_E_GATE_CDEFGH.n48 ota_cmfb_top_0.dynamic_pcell$5_0.DRN_NET_E_GATE_CDEFGH 1.72976
R10710 ota_cmfb_top_0.dynamic_pcell$5_0.DRN_NET_E_GATE_CDEFGH.t11 ota_cmfb_top_0.dynamic_pcell$5_0.DRN_NET_E_GATE_CDEFGH 1.67732
R10711 ota_cmfb_top_0.dynamic_pcell$5_0.DRN_NET_E_GATE_CDEFGH ota_cmfb_top_0.dynamic_pcell$5_0.DRN_NET_E_GATE_CDEFGH.n3 1.42561
R10712 ota_cmfb_top_0.dynamic_pcell$5_0.DRN_NET_E_GATE_CDEFGH.n53 ota_cmfb_top_0.dynamic_pcell$5_0.DRN_NET_E_GATE_CDEFGH 1.38088
R10713 ota_cmfb_top_0.dynamic_pcell$5_0.DRN_NET_E_GATE_CDEFGH.n35 ota_cmfb_top_0.dynamic_pcell$5_0.DRN_NET_E_GATE_CDEFGH 1.38088
R10714 ota_cmfb_top_0.dynamic_pcell$5_0.DRN_NET_E_GATE_CDEFGH.n23 ota_cmfb_top_0.dynamic_pcell$5_0.DRN_NET_E_GATE_CDEFGH 1.38088
R10715 ota_cmfb_top_0.dynamic_pcell$5_0.DRN_NET_E_GATE_CDEFGH.n21 ota_cmfb_top_0.dynamic_pcell$5_0.DRN_NET_E_GATE_CDEFGH 1.38088
R10716 ota_cmfb_top_0.dynamic_pcell$5_0.F_DRN.n52 ota_cmfb_top_0.dynamic_pcell$5_0.F_DRN 42.917
R10717 ota_cmfb_top_0.dynamic_pcell$5_0.F_DRN.n26 ota_cmfb_top_0.dynamic_pcell$5_0.F_DRN.t3 37.8988
R10718 ota_cmfb_top_0.dynamic_pcell$5_0.F_DRN ota_cmfb_top_0.dynamic_pcell$5_0.F_DRN.t1 26.495
R10719 ota_cmfb_top_0.dynamic_pcell$5_0.F_DRN ota_cmfb_top_0.dynamic_pcell$5_0.F_DRN.t2 26.2926
R10720 ota_cmfb_top_0.dynamic_pcell$5_0.F_DRN.n2 ota_cmfb_top_0.dynamic_pcell$5_0.F_DRN 3.68405
R10721 ota_cmfb_top_0.dynamic_pcell$5_0.F_DRN.n4 ota_cmfb_top_0.dynamic_pcell$5_0.F_DRN 3.68405
R10722 ota_cmfb_top_0.dynamic_pcell$5_0.F_DRN.n33 ota_cmfb_top_0.dynamic_pcell$5_0.F_DRN.n31 14.2664
R10723 ota_cmfb_top_0.dynamic_pcell$5_0.F_DRN.n33 ota_cmfb_top_0.dynamic_pcell$5_0.F_DRN 14.1793
R10724 ota_cmfb_top_0.dynamic_pcell$5_0.F_DRN.n58 ota_cmfb_top_0.dynamic_pcell$5_0.F_DRN.n55 13.6513
R10725 ota_cmfb_top_0.dynamic_pcell$5_0.F_DRN.n52 ota_cmfb_top_0.dynamic_pcell$5_0.F_DRN.n51 11.9177
R10726 ota_cmfb_top_0.dynamic_pcell$5_0.F_DRN.n44 ota_cmfb_top_0.dynamic_pcell$5_0.F_DRN.n43 11.9177
R10727 ota_cmfb_top_0.dynamic_pcell$5_0.F_DRN.n54 ota_cmfb_top_0.dynamic_pcell$5_0.F_DRN 11.0817
R10728 ota_cmfb_top_0.dynamic_pcell$5_0.F_DRN ota_cmfb_top_0.dynamic_pcell$5_0.F_DRN.n61 10.7709
R10729 ota_cmfb_top_0.dynamic_pcell$5_0.F_DRN.n41 ota_cmfb_top_0.dynamic_pcell$5_0.F_DRN 10.067
R10730 ota_cmfb_top_0.dynamic_pcell$5_0.F_DRN.n57 ota_cmfb_top_0.dynamic_pcell$5_0.F_DRN 10.0494
R10731 ota_cmfb_top_0.dynamic_pcell$5_0.F_DRN.n59 ota_cmfb_top_0.dynamic_pcell$5_0.F_DRN 10.0494
R10732 ota_cmfb_top_0.dynamic_pcell$5_0.F_DRN.n34 ota_cmfb_top_0.dynamic_pcell$5_0.F_DRN 9.74585
R10733 ota_cmfb_top_0.dynamic_pcell$5_0.F_DRN.n38 ota_cmfb_top_0.dynamic_pcell$5_0.F_DRN 9.74585
R10734 ota_cmfb_top_0.dynamic_pcell$5_0.F_DRN.n47 ota_cmfb_top_0.dynamic_pcell$5_0.F_DRN 9.0005
R10735 ota_cmfb_top_0.dynamic_pcell$5_0.F_DRN.n48 ota_cmfb_top_0.dynamic_pcell$5_0.F_DRN 9.0005
R10736 ota_cmfb_top_0.dynamic_pcell$5_0.F_DRN ota_cmfb_top_0.dynamic_pcell$5_0.F_DRN.n49 9.0005
R10737 ota_cmfb_top_0.dynamic_pcell$5_0.F_DRN.n11 ota_cmfb_top_0.dynamic_pcell$5_0.F_DRN 4.44881
R10738 ota_cmfb_top_0.dynamic_pcell$5_0.F_DRN ota_cmfb_top_0.dynamic_pcell$5_0.F_DRN.n50 9.0005
R10739 ota_cmfb_top_0.dynamic_pcell$5_0.F_DRN.n46 ota_cmfb_top_0.dynamic_pcell$5_0.F_DRN 9.0005
R10740 ota_cmfb_top_0.dynamic_pcell$5_0.F_DRN.n45 ota_cmfb_top_0.dynamic_pcell$5_0.F_DRN 9.0005
R10741 ota_cmfb_top_0.dynamic_pcell$5_0.F_DRN ota_cmfb_top_0.dynamic_pcell$5_0.F_DRN.n10 4.5088
R10742 ota_cmfb_top_0.dynamic_pcell$5_0.F_DRN.n2 ota_cmfb_top_0.dynamic_pcell$5_0.F_DRN.n1 0.384311
R10743 ota_cmfb_top_0.dynamic_pcell$5_0.F_DRN.n27 ota_cmfb_top_0.dynamic_pcell$5_0.F_DRN 9.0005
R10744 ota_cmfb_top_0.dynamic_pcell$5_0.F_DRN.n28 ota_cmfb_top_0.dynamic_pcell$5_0.F_DRN 9.0005
R10745 ota_cmfb_top_0.dynamic_pcell$5_0.F_DRN ota_cmfb_top_0.dynamic_pcell$5_0.F_DRN.n29 9.0005
R10746 ota_cmfb_top_0.dynamic_pcell$5_0.F_DRN.n13 ota_cmfb_top_0.dynamic_pcell$5_0.F_DRN 4.44881
R10747 ota_cmfb_top_0.dynamic_pcell$5_0.F_DRN ota_cmfb_top_0.dynamic_pcell$5_0.F_DRN.n30 9.0005
R10748 ota_cmfb_top_0.dynamic_pcell$5_0.F_DRN.n25 ota_cmfb_top_0.dynamic_pcell$5_0.F_DRN 9.0005
R10749 ota_cmfb_top_0.dynamic_pcell$5_0.F_DRN.n24 ota_cmfb_top_0.dynamic_pcell$5_0.F_DRN 9.0005
R10750 ota_cmfb_top_0.dynamic_pcell$5_0.F_DRN ota_cmfb_top_0.dynamic_pcell$5_0.F_DRN.n12 4.5088
R10751 ota_cmfb_top_0.dynamic_pcell$5_0.F_DRN.n4 ota_cmfb_top_0.dynamic_pcell$5_0.F_DRN.n3 0.384311
R10752 ota_cmfb_top_0.dynamic_pcell$5_0.F_DRN.n41 ota_cmfb_top_0.dynamic_pcell$5_0.F_DRN 9.0005
R10753 ota_cmfb_top_0.dynamic_pcell$5_0.F_DRN ota_cmfb_top_0.dynamic_pcell$5_0.F_DRN.n42 9.0005
R10754 ota_cmfb_top_0.dynamic_pcell$5_0.F_DRN.n40 ota_cmfb_top_0.dynamic_pcell$5_0.F_DRN 9.0005
R10755 ota_cmfb_top_0.dynamic_pcell$5_0.F_DRN ota_cmfb_top_0.dynamic_pcell$5_0.F_DRN.n6 4.53084
R10756 ota_cmfb_top_0.dynamic_pcell$5_0.F_DRN.n5 ota_cmfb_top_0.dynamic_pcell$5_0.F_DRN 9.0005
R10757 ota_cmfb_top_0.dynamic_pcell$5_0.F_DRN ota_cmfb_top_0.dynamic_pcell$5_0.F_DRN.n7 9.0005
R10758 ota_cmfb_top_0.dynamic_pcell$5_0.F_DRN ota_cmfb_top_0.dynamic_pcell$5_0.F_DRN.n39 9.0005
R10759 ota_cmfb_top_0.dynamic_pcell$5_0.F_DRN.n8 ota_cmfb_top_0.dynamic_pcell$5_0.F_DRN 4.53084
R10760 ota_cmfb_top_0.dynamic_pcell$5_0.F_DRN.n36 ota_cmfb_top_0.dynamic_pcell$5_0.F_DRN 9.0005
R10761 ota_cmfb_top_0.dynamic_pcell$5_0.F_DRN ota_cmfb_top_0.dynamic_pcell$5_0.F_DRN.n37 9.0005
R10762 ota_cmfb_top_0.dynamic_pcell$5_0.F_DRN.n35 ota_cmfb_top_0.dynamic_pcell$5_0.F_DRN 9.0005
R10763 ota_cmfb_top_0.dynamic_pcell$5_0.F_DRN ota_cmfb_top_0.dynamic_pcell$5_0.F_DRN.n9 4.53084
R10764 ota_cmfb_top_0.dynamic_pcell$5_0.F_DRN.n0 ota_cmfb_top_0.dynamic_pcell$5_0.F_DRN 1.65742
R10765 ota_cmfb_top_0.dynamic_pcell$5_0.F_DRN.n0 ota_cmfb_top_0.dynamic_pcell$5_0.F_DRN.n34 0.662883
R10766 ota_cmfb_top_0.dynamic_pcell$5_0.F_DRN.n15 ota_cmfb_top_0.dynamic_pcell$5_0.F_DRN 4.3094
R10767 ota_cmfb_top_0.dynamic_pcell$5_0.F_DRN.n2 ota_cmfb_top_0.dynamic_pcell$5_0.F_DRN 4.63344
R10768 ota_cmfb_top_0.dynamic_pcell$5_0.F_DRN.n1 ota_cmfb_top_0.dynamic_pcell$5_0.F_DRN 7.61987
R10769 ota_cmfb_top_0.dynamic_pcell$5_0.F_DRN ota_cmfb_top_0.dynamic_pcell$5_0.F_DRN.n16 4.3094
R10770 ota_cmfb_top_0.dynamic_pcell$5_0.F_DRN.n17 ota_cmfb_top_0.dynamic_pcell$5_0.F_DRN 4.3094
R10771 ota_cmfb_top_0.dynamic_pcell$5_0.F_DRN ota_cmfb_top_0.dynamic_pcell$5_0.F_DRN.n18 4.3094
R10772 ota_cmfb_top_0.dynamic_pcell$5_0.F_DRN.n19 ota_cmfb_top_0.dynamic_pcell$5_0.F_DRN 4.3094
R10773 ota_cmfb_top_0.dynamic_pcell$5_0.F_DRN.n4 ota_cmfb_top_0.dynamic_pcell$5_0.F_DRN 4.63344
R10774 ota_cmfb_top_0.dynamic_pcell$5_0.F_DRN.n3 ota_cmfb_top_0.dynamic_pcell$5_0.F_DRN 7.61987
R10775 ota_cmfb_top_0.dynamic_pcell$5_0.F_DRN ota_cmfb_top_0.dynamic_pcell$5_0.F_DRN.n20 4.3094
R10776 ota_cmfb_top_0.dynamic_pcell$5_0.F_DRN.n21 ota_cmfb_top_0.dynamic_pcell$5_0.F_DRN 4.30962
R10777 ota_cmfb_top_0.dynamic_pcell$5_0.F_DRN ota_cmfb_top_0.dynamic_pcell$5_0.F_DRN.n22 4.30962
R10778 ota_cmfb_top_0.dynamic_pcell$5_0.F_DRN.n14 ota_cmfb_top_0.dynamic_pcell$5_0.F_DRN 4.30901
R10779 ota_cmfb_top_0.dynamic_pcell$5_0.F_DRN ota_cmfb_top_0.dynamic_pcell$5_0.F_DRN.t12 5.55474
R10780 ota_cmfb_top_0.dynamic_pcell$5_0.F_DRN ota_cmfb_top_0.dynamic_pcell$5_0.F_DRN.t10 5.55474
R10781 ota_cmfb_top_0.dynamic_pcell$5_0.F_DRN ota_cmfb_top_0.dynamic_pcell$5_0.F_DRN.t7 5.25114
R10782 ota_cmfb_top_0.dynamic_pcell$5_0.F_DRN ota_cmfb_top_0.dynamic_pcell$5_0.F_DRN.t5 5.25114
R10783 ota_cmfb_top_0.dynamic_pcell$5_0.F_DRN ota_cmfb_top_0.dynamic_pcell$5_0.F_DRN.t4 5.25114
R10784 ota_cmfb_top_0.dynamic_pcell$5_0.F_DRN ota_cmfb_top_0.dynamic_pcell$5_0.F_DRN.n14 0.0168263
R10785 ota_cmfb_top_0.dynamic_pcell$5_0.F_DRN ota_cmfb_top_0.dynamic_pcell$5_0.F_DRN.n15 0.0125004
R10786 ota_cmfb_top_0.dynamic_pcell$5_0.F_DRN ota_cmfb_top_0.dynamic_pcell$5_0.F_DRN.n17 0.0125004
R10787 ota_cmfb_top_0.dynamic_pcell$5_0.F_DRN ota_cmfb_top_0.dynamic_pcell$5_0.F_DRN.n19 0.0125004
R10788 ota_cmfb_top_0.dynamic_pcell$5_0.F_DRN ota_cmfb_top_0.dynamic_pcell$5_0.F_DRN.n21 0.0100317
R10789 ota_cmfb_top_0.dynamic_pcell$5_0.F_DRN ota_cmfb_top_0.dynamic_pcell$5_0.F_DRN.n32 3.9341
R10790 ota_cmfb_top_0.dynamic_pcell$5_0.F_DRN.n47 ota_cmfb_top_0.dynamic_pcell$5_0.F_DRN.n16 3.84101
R10791 ota_cmfb_top_0.dynamic_pcell$5_0.F_DRN.n18 ota_cmfb_top_0.dynamic_pcell$5_0.F_DRN 3.51981
R10792 ota_cmfb_top_0.dynamic_pcell$5_0.F_DRN.n22 ota_cmfb_top_0.dynamic_pcell$5_0.F_DRN 3.51612
R10793 ota_cmfb_top_0.dynamic_pcell$5_0.F_DRN ota_cmfb_top_0.dynamic_pcell$5_0.F_DRN.n16 0.0125004
R10794 ota_cmfb_top_0.dynamic_pcell$5_0.F_DRN ota_cmfb_top_0.dynamic_pcell$5_0.F_DRN.n18 0.0125004
R10795 ota_cmfb_top_0.dynamic_pcell$5_0.F_DRN ota_cmfb_top_0.dynamic_pcell$5_0.F_DRN.n20 0.0125004
R10796 ota_cmfb_top_0.dynamic_pcell$5_0.F_DRN ota_cmfb_top_0.dynamic_pcell$5_0.F_DRN.n22 0.0100317
R10797 ota_cmfb_top_0.dynamic_pcell$5_0.F_DRN ota_cmfb_top_0.dynamic_pcell$5_0.F_DRN.n58 3.0445
R10798 ota_cmfb_top_0.dynamic_pcell$5_0.F_DRN.n51 ota_cmfb_top_0.dynamic_pcell$5_0.F_DRN.n15 3.0182
R10799 ota_cmfb_top_0.dynamic_pcell$5_0.F_DRN.n53 ota_cmfb_top_0.dynamic_pcell$5_0.F_DRN.n17 3.0182
R10800 ota_cmfb_top_0.dynamic_pcell$5_0.F_DRN.n20 ota_cmfb_top_0.dynamic_pcell$5_0.F_DRN.n26 3.0182
R10801 ota_cmfb_top_0.dynamic_pcell$5_0.F_DRN.n31 ota_cmfb_top_0.dynamic_pcell$5_0.F_DRN.n19 3.0182
R10802 ota_cmfb_top_0.dynamic_pcell$5_0.F_DRN.n32 ota_cmfb_top_0.dynamic_pcell$5_0.F_DRN.n21 3.01452
R10803 ota_cmfb_top_0.dynamic_pcell$5_0.F_DRN.n43 ota_cmfb_top_0.dynamic_pcell$5_0.F_DRN.n14 3.02465
R10804 ota_cmfb_top_0.dynamic_pcell$5_0.F_DRN.n55 ota_cmfb_top_0.dynamic_pcell$5_0.F_DRN.n54 2.95639
R10805 ota_cmfb_top_0.dynamic_pcell$5_0.F_DRN.n44 ota_cmfb_top_0.dynamic_pcell$5_0.F_DRN.n33 2.95639
R10806 ota_cmfb_top_0.dynamic_pcell$5_0.F_DRN.n54 ota_cmfb_top_0.dynamic_pcell$5_0.F_DRN.n52 2.55159
R10807 ota_cmfb_top_0.dynamic_pcell$5_0.F_DRN ota_cmfb_top_0.dynamic_pcell$5_0.F_DRN.n11 2.03698
R10808 ota_cmfb_top_0.dynamic_pcell$5_0.F_DRN ota_cmfb_top_0.dynamic_pcell$5_0.F_DRN.n13 2.03698
R10809 ota_cmfb_top_0.dynamic_pcell$5_0.F_DRN.n61 ota_cmfb_top_0.dynamic_pcell$5_0.F_DRN 1.68733
R10810 ota_cmfb_top_0.dynamic_pcell$5_0.F_DRN.n60 ota_cmfb_top_0.dynamic_pcell$5_0.F_DRN 1.68733
R10811 ota_cmfb_top_0.dynamic_pcell$5_0.F_DRN.n23 ota_cmfb_top_0.dynamic_pcell$5_0.F_DRN 1.68733
R10812 ota_cmfb_top_0.dynamic_pcell$5_0.F_DRN.n56 ota_cmfb_top_0.dynamic_pcell$5_0.F_DRN 1.68722
R10813 ota_cmfb_top_0.dynamic_pcell$5_0.F_DRN.n23 ota_cmfb_top_0.dynamic_pcell$5_0.F_DRN.n56 1.44547
R10814 ota_cmfb_top_0.dynamic_pcell$5_0.F_DRN.n61 ota_cmfb_top_0.dynamic_pcell$5_0.F_DRN.n60 1.44482
R10815 ota_cmfb_top_0.dynamic_pcell$5_0.F_DRN ota_cmfb_top_0.dynamic_pcell$5_0.F_DRN.n44 1.07364
R10816 ota_cmfb_top_0.dynamic_pcell$5_0.F_DRN.n55 ota_cmfb_top_0.dynamic_pcell$5_0.F_DRN 0.871245
R10817 ota_cmfb_top_0.dynamic_pcell$5_0.F_DRN ota_cmfb_top_0.dynamic_pcell$5_0.F_DRN.n53 0.8365
R10818 ota_cmfb_top_0.dynamic_pcell$5_0.F_DRN.n51 ota_cmfb_top_0.dynamic_pcell$5_0.F_DRN.n10 0.928175
R10819 ota_cmfb_top_0.dynamic_pcell$5_0.F_DRN.n27 ota_cmfb_top_0.dynamic_pcell$5_0.F_DRN.n26 0.8233
R10820 ota_cmfb_top_0.dynamic_pcell$5_0.F_DRN.n31 ota_cmfb_top_0.dynamic_pcell$5_0.F_DRN.n12 0.928175
R10821 ota_cmfb_top_0.dynamic_pcell$5_0.F_DRN.n60 ota_cmfb_top_0.dynamic_pcell$5_0.F_DRN.n59 0.72332
R10822 ota_cmfb_top_0.dynamic_pcell$5_0.F_DRN.n57 ota_cmfb_top_0.dynamic_pcell$5_0.F_DRN.n56 0.722599
R10823 ota_cmfb_top_0.dynamic_pcell$5_0.F_DRN.n23 ota_cmfb_top_0.dynamic_pcell$5_0.F_DRN.n59 0.722001
R10824 ota_cmfb_top_0.dynamic_pcell$5_0.F_DRN.n6 ota_cmfb_top_0.dynamic_pcell$5_0.F_DRN.n5 0.747775
R10825 ota_cmfb_top_0.dynamic_pcell$5_0.F_DRN.n50 ota_cmfb_top_0.dynamic_pcell$5_0.F_DRN 0.5945
R10826 ota_cmfb_top_0.dynamic_pcell$5_0.F_DRN.n30 ota_cmfb_top_0.dynamic_pcell$5_0.F_DRN 0.5945
R10827 ota_cmfb_top_0.dynamic_pcell$5_0.F_DRN.n58 ota_cmfb_top_0.dynamic_pcell$5_0.F_DRN.n57 0.5021
R10828 ota_cmfb_top_0.dynamic_pcell$5_0.F_DRN.n53 ota_cmfb_top_0.dynamic_pcell$5_0.F_DRN 0.5021
R10829 ota_cmfb_top_0.dynamic_pcell$5_0.F_DRN.n32 ota_cmfb_top_0.dynamic_pcell$5_0.F_DRN 0.5021
R10830 ota_cmfb_top_0.dynamic_pcell$5_0.F_DRN.n43 ota_cmfb_top_0.dynamic_pcell$5_0.F_DRN.n34 0.5021
R10831 ota_cmfb_top_0.dynamic_pcell$5_0.F_DRN ota_cmfb_top_0.dynamic_pcell$5_0.F_DRN.t0 5.55211
R10832 ota_cmfb_top_0.dynamic_pcell$5_0.F_DRN ota_cmfb_top_0.dynamic_pcell$5_0.F_DRN.n3 3.03363
R10833 ota_cmfb_top_0.dynamic_pcell$5_0.F_DRN ota_cmfb_top_0.dynamic_pcell$5_0.F_DRN.n1 3.03363
R10834 ota_cmfb_top_0.dynamic_pcell$5_0.F_DRN.n8 ota_cmfb_top_0.dynamic_pcell$5_0.F_DRN.n38 0.426575
R10835 ota_cmfb_top_0.dynamic_pcell$5_0.F_DRN.n38 ota_cmfb_top_0.dynamic_pcell$5_0.F_DRN.n36 0.3217
R10836 ota_cmfb_top_0.dynamic_pcell$5_0.F_DRN.n37 ota_cmfb_top_0.dynamic_pcell$5_0.F_DRN.n36 0.2117
R10837 ota_cmfb_top_0.dynamic_pcell$5_0.F_DRN.n48 ota_cmfb_top_0.dynamic_pcell$5_0.F_DRN.n47 0.2117
R10838 ota_cmfb_top_0.dynamic_pcell$5_0.F_DRN.n49 ota_cmfb_top_0.dynamic_pcell$5_0.F_DRN.n48 0.2117
R10839 ota_cmfb_top_0.dynamic_pcell$5_0.F_DRN.n49 ota_cmfb_top_0.dynamic_pcell$5_0.F_DRN.n11 0.316575
R10840 ota_cmfb_top_0.dynamic_pcell$5_0.F_DRN.n50 ota_cmfb_top_0.dynamic_pcell$5_0.F_DRN.n46 0.2117
R10841 ota_cmfb_top_0.dynamic_pcell$5_0.F_DRN.n46 ota_cmfb_top_0.dynamic_pcell$5_0.F_DRN.n45 0.2117
R10842 ota_cmfb_top_0.dynamic_pcell$5_0.F_DRN.n45 ota_cmfb_top_0.dynamic_pcell$5_0.F_DRN.n10 0.316575
R10843 ota_cmfb_top_0.dynamic_pcell$5_0.F_DRN.n28 ota_cmfb_top_0.dynamic_pcell$5_0.F_DRN.n27 0.2117
R10844 ota_cmfb_top_0.dynamic_pcell$5_0.F_DRN.n29 ota_cmfb_top_0.dynamic_pcell$5_0.F_DRN.n28 0.2117
R10845 ota_cmfb_top_0.dynamic_pcell$5_0.F_DRN.n29 ota_cmfb_top_0.dynamic_pcell$5_0.F_DRN.n13 0.316575
R10846 ota_cmfb_top_0.dynamic_pcell$5_0.F_DRN.n30 ota_cmfb_top_0.dynamic_pcell$5_0.F_DRN.n25 0.2117
R10847 ota_cmfb_top_0.dynamic_pcell$5_0.F_DRN.n25 ota_cmfb_top_0.dynamic_pcell$5_0.F_DRN.n24 0.2117
R10848 ota_cmfb_top_0.dynamic_pcell$5_0.F_DRN.n24 ota_cmfb_top_0.dynamic_pcell$5_0.F_DRN.n12 0.316575
R10849 ota_cmfb_top_0.dynamic_pcell$5_0.F_DRN.n42 ota_cmfb_top_0.dynamic_pcell$5_0.F_DRN.n41 0.2117
R10850 ota_cmfb_top_0.dynamic_pcell$5_0.F_DRN.n42 ota_cmfb_top_0.dynamic_pcell$5_0.F_DRN.n40 0.2117
R10851 ota_cmfb_top_0.dynamic_pcell$5_0.F_DRN.n40 ota_cmfb_top_0.dynamic_pcell$5_0.F_DRN.n6 0.316575
R10852 ota_cmfb_top_0.dynamic_pcell$5_0.F_DRN.n5 ota_cmfb_top_0.dynamic_pcell$5_0.F_DRN.n7 0.2117
R10853 ota_cmfb_top_0.dynamic_pcell$5_0.F_DRN.n39 ota_cmfb_top_0.dynamic_pcell$5_0.F_DRN.n7 0.2117
R10854 ota_cmfb_top_0.dynamic_pcell$5_0.F_DRN.n39 ota_cmfb_top_0.dynamic_pcell$5_0.F_DRN.n8 0.316575
R10855 ota_cmfb_top_0.dynamic_pcell$5_0.F_DRN.n37 ota_cmfb_top_0.dynamic_pcell$5_0.F_DRN.n35 0.2117
R10856 ota_cmfb_top_0.dynamic_pcell$5_0.F_DRN.n35 ota_cmfb_top_0.dynamic_pcell$5_0.F_DRN.n9 0.316575
R10857 ota_cmfb_top_0.dynamic_pcell$5_0.F_DRN.n9 ota_cmfb_top_0.dynamic_pcell$5_0.F_DRN.n0 1.20015
R10858 ota_cmfb_top_0.dynamic_pcell$5_0.G_DRN.n52 ota_cmfb_top_0.dynamic_pcell$5_0.G_DRN 45.8716
R10859 ota_cmfb_top_0.dynamic_pcell$5_0.G_DRN.n26 ota_cmfb_top_0.dynamic_pcell$5_0.G_DRN.t13 37.8988
R10860 ota_cmfb_top_0.dynamic_pcell$5_0.G_DRN ota_cmfb_top_0.dynamic_pcell$5_0.G_DRN.t2 26.5962
R10861 ota_cmfb_top_0.dynamic_pcell$5_0.G_DRN ota_cmfb_top_0.dynamic_pcell$5_0.G_DRN.t1 26.1914
R10862 ota_cmfb_top_0.dynamic_pcell$5_0.G_DRN.n2 ota_cmfb_top_0.dynamic_pcell$5_0.G_DRN 3.68405
R10863 ota_cmfb_top_0.dynamic_pcell$5_0.G_DRN.n4 ota_cmfb_top_0.dynamic_pcell$5_0.G_DRN 3.68405
R10864 ota_cmfb_top_0.dynamic_pcell$5_0.G_DRN.n33 ota_cmfb_top_0.dynamic_pcell$5_0.G_DRN.n31 14.2664
R10865 ota_cmfb_top_0.dynamic_pcell$5_0.G_DRN.n33 ota_cmfb_top_0.dynamic_pcell$5_0.G_DRN 14.1793
R10866 ota_cmfb_top_0.dynamic_pcell$5_0.G_DRN.n58 ota_cmfb_top_0.dynamic_pcell$5_0.G_DRN.n55 13.6513
R10867 ota_cmfb_top_0.dynamic_pcell$5_0.G_DRN.n52 ota_cmfb_top_0.dynamic_pcell$5_0.G_DRN.n51 11.9177
R10868 ota_cmfb_top_0.dynamic_pcell$5_0.G_DRN.n44 ota_cmfb_top_0.dynamic_pcell$5_0.G_DRN.n43 11.9177
R10869 ota_cmfb_top_0.dynamic_pcell$5_0.G_DRN.n54 ota_cmfb_top_0.dynamic_pcell$5_0.G_DRN 11.0817
R10870 ota_cmfb_top_0.dynamic_pcell$5_0.G_DRN ota_cmfb_top_0.dynamic_pcell$5_0.G_DRN.n61 10.7709
R10871 ota_cmfb_top_0.dynamic_pcell$5_0.G_DRN.n41 ota_cmfb_top_0.dynamic_pcell$5_0.G_DRN 10.067
R10872 ota_cmfb_top_0.dynamic_pcell$5_0.G_DRN.n57 ota_cmfb_top_0.dynamic_pcell$5_0.G_DRN 10.0494
R10873 ota_cmfb_top_0.dynamic_pcell$5_0.G_DRN.n59 ota_cmfb_top_0.dynamic_pcell$5_0.G_DRN 10.0494
R10874 ota_cmfb_top_0.dynamic_pcell$5_0.G_DRN.n34 ota_cmfb_top_0.dynamic_pcell$5_0.G_DRN 9.74585
R10875 ota_cmfb_top_0.dynamic_pcell$5_0.G_DRN.n38 ota_cmfb_top_0.dynamic_pcell$5_0.G_DRN 9.74585
R10876 ota_cmfb_top_0.dynamic_pcell$5_0.G_DRN.n47 ota_cmfb_top_0.dynamic_pcell$5_0.G_DRN 9.0005
R10877 ota_cmfb_top_0.dynamic_pcell$5_0.G_DRN.n48 ota_cmfb_top_0.dynamic_pcell$5_0.G_DRN 9.0005
R10878 ota_cmfb_top_0.dynamic_pcell$5_0.G_DRN ota_cmfb_top_0.dynamic_pcell$5_0.G_DRN.n49 9.0005
R10879 ota_cmfb_top_0.dynamic_pcell$5_0.G_DRN.n11 ota_cmfb_top_0.dynamic_pcell$5_0.G_DRN 4.44881
R10880 ota_cmfb_top_0.dynamic_pcell$5_0.G_DRN ota_cmfb_top_0.dynamic_pcell$5_0.G_DRN.n50 9.0005
R10881 ota_cmfb_top_0.dynamic_pcell$5_0.G_DRN.n46 ota_cmfb_top_0.dynamic_pcell$5_0.G_DRN 9.0005
R10882 ota_cmfb_top_0.dynamic_pcell$5_0.G_DRN.n45 ota_cmfb_top_0.dynamic_pcell$5_0.G_DRN 9.0005
R10883 ota_cmfb_top_0.dynamic_pcell$5_0.G_DRN ota_cmfb_top_0.dynamic_pcell$5_0.G_DRN.n10 4.5088
R10884 ota_cmfb_top_0.dynamic_pcell$5_0.G_DRN.n2 ota_cmfb_top_0.dynamic_pcell$5_0.G_DRN.n1 0.384311
R10885 ota_cmfb_top_0.dynamic_pcell$5_0.G_DRN.n27 ota_cmfb_top_0.dynamic_pcell$5_0.G_DRN 9.0005
R10886 ota_cmfb_top_0.dynamic_pcell$5_0.G_DRN.n28 ota_cmfb_top_0.dynamic_pcell$5_0.G_DRN 9.0005
R10887 ota_cmfb_top_0.dynamic_pcell$5_0.G_DRN ota_cmfb_top_0.dynamic_pcell$5_0.G_DRN.n29 9.0005
R10888 ota_cmfb_top_0.dynamic_pcell$5_0.G_DRN.n13 ota_cmfb_top_0.dynamic_pcell$5_0.G_DRN 4.44881
R10889 ota_cmfb_top_0.dynamic_pcell$5_0.G_DRN ota_cmfb_top_0.dynamic_pcell$5_0.G_DRN.n30 9.0005
R10890 ota_cmfb_top_0.dynamic_pcell$5_0.G_DRN.n25 ota_cmfb_top_0.dynamic_pcell$5_0.G_DRN 9.0005
R10891 ota_cmfb_top_0.dynamic_pcell$5_0.G_DRN.n24 ota_cmfb_top_0.dynamic_pcell$5_0.G_DRN 9.0005
R10892 ota_cmfb_top_0.dynamic_pcell$5_0.G_DRN ota_cmfb_top_0.dynamic_pcell$5_0.G_DRN.n12 4.5088
R10893 ota_cmfb_top_0.dynamic_pcell$5_0.G_DRN.n4 ota_cmfb_top_0.dynamic_pcell$5_0.G_DRN.n3 0.384311
R10894 ota_cmfb_top_0.dynamic_pcell$5_0.G_DRN.n41 ota_cmfb_top_0.dynamic_pcell$5_0.G_DRN 9.0005
R10895 ota_cmfb_top_0.dynamic_pcell$5_0.G_DRN ota_cmfb_top_0.dynamic_pcell$5_0.G_DRN.n42 9.0005
R10896 ota_cmfb_top_0.dynamic_pcell$5_0.G_DRN.n40 ota_cmfb_top_0.dynamic_pcell$5_0.G_DRN 9.0005
R10897 ota_cmfb_top_0.dynamic_pcell$5_0.G_DRN ota_cmfb_top_0.dynamic_pcell$5_0.G_DRN.n6 4.53084
R10898 ota_cmfb_top_0.dynamic_pcell$5_0.G_DRN.n5 ota_cmfb_top_0.dynamic_pcell$5_0.G_DRN 9.0005
R10899 ota_cmfb_top_0.dynamic_pcell$5_0.G_DRN ota_cmfb_top_0.dynamic_pcell$5_0.G_DRN.n7 9.0005
R10900 ota_cmfb_top_0.dynamic_pcell$5_0.G_DRN ota_cmfb_top_0.dynamic_pcell$5_0.G_DRN.n39 9.0005
R10901 ota_cmfb_top_0.dynamic_pcell$5_0.G_DRN.n8 ota_cmfb_top_0.dynamic_pcell$5_0.G_DRN 4.53084
R10902 ota_cmfb_top_0.dynamic_pcell$5_0.G_DRN.n36 ota_cmfb_top_0.dynamic_pcell$5_0.G_DRN 9.0005
R10903 ota_cmfb_top_0.dynamic_pcell$5_0.G_DRN ota_cmfb_top_0.dynamic_pcell$5_0.G_DRN.n37 9.0005
R10904 ota_cmfb_top_0.dynamic_pcell$5_0.G_DRN.n35 ota_cmfb_top_0.dynamic_pcell$5_0.G_DRN 9.0005
R10905 ota_cmfb_top_0.dynamic_pcell$5_0.G_DRN ota_cmfb_top_0.dynamic_pcell$5_0.G_DRN.n9 4.53084
R10906 ota_cmfb_top_0.dynamic_pcell$5_0.G_DRN.n0 ota_cmfb_top_0.dynamic_pcell$5_0.G_DRN 1.65742
R10907 ota_cmfb_top_0.dynamic_pcell$5_0.G_DRN.n0 ota_cmfb_top_0.dynamic_pcell$5_0.G_DRN.n34 0.662883
R10908 ota_cmfb_top_0.dynamic_pcell$5_0.G_DRN.n15 ota_cmfb_top_0.dynamic_pcell$5_0.G_DRN 4.3094
R10909 ota_cmfb_top_0.dynamic_pcell$5_0.G_DRN.n2 ota_cmfb_top_0.dynamic_pcell$5_0.G_DRN 4.63344
R10910 ota_cmfb_top_0.dynamic_pcell$5_0.G_DRN.n1 ota_cmfb_top_0.dynamic_pcell$5_0.G_DRN 7.61987
R10911 ota_cmfb_top_0.dynamic_pcell$5_0.G_DRN ota_cmfb_top_0.dynamic_pcell$5_0.G_DRN.n16 4.3094
R10912 ota_cmfb_top_0.dynamic_pcell$5_0.G_DRN.n17 ota_cmfb_top_0.dynamic_pcell$5_0.G_DRN 4.3094
R10913 ota_cmfb_top_0.dynamic_pcell$5_0.G_DRN ota_cmfb_top_0.dynamic_pcell$5_0.G_DRN.n18 4.3094
R10914 ota_cmfb_top_0.dynamic_pcell$5_0.G_DRN.n19 ota_cmfb_top_0.dynamic_pcell$5_0.G_DRN 4.3094
R10915 ota_cmfb_top_0.dynamic_pcell$5_0.G_DRN.n4 ota_cmfb_top_0.dynamic_pcell$5_0.G_DRN 4.63344
R10916 ota_cmfb_top_0.dynamic_pcell$5_0.G_DRN.n3 ota_cmfb_top_0.dynamic_pcell$5_0.G_DRN 7.61987
R10917 ota_cmfb_top_0.dynamic_pcell$5_0.G_DRN ota_cmfb_top_0.dynamic_pcell$5_0.G_DRN.n20 4.3094
R10918 ota_cmfb_top_0.dynamic_pcell$5_0.G_DRN.n21 ota_cmfb_top_0.dynamic_pcell$5_0.G_DRN 4.30962
R10919 ota_cmfb_top_0.dynamic_pcell$5_0.G_DRN ota_cmfb_top_0.dynamic_pcell$5_0.G_DRN.n22 4.30962
R10920 ota_cmfb_top_0.dynamic_pcell$5_0.G_DRN.n14 ota_cmfb_top_0.dynamic_pcell$5_0.G_DRN 4.30901
R10921 ota_cmfb_top_0.dynamic_pcell$5_0.G_DRN ota_cmfb_top_0.dynamic_pcell$5_0.G_DRN.t11 5.55474
R10922 ota_cmfb_top_0.dynamic_pcell$5_0.G_DRN ota_cmfb_top_0.dynamic_pcell$5_0.G_DRN.t9 5.55474
R10923 ota_cmfb_top_0.dynamic_pcell$5_0.G_DRN ota_cmfb_top_0.dynamic_pcell$5_0.G_DRN.t6 5.25114
R10924 ota_cmfb_top_0.dynamic_pcell$5_0.G_DRN ota_cmfb_top_0.dynamic_pcell$5_0.G_DRN.t4 5.25114
R10925 ota_cmfb_top_0.dynamic_pcell$5_0.G_DRN ota_cmfb_top_0.dynamic_pcell$5_0.G_DRN.t3 5.25114
R10926 ota_cmfb_top_0.dynamic_pcell$5_0.G_DRN ota_cmfb_top_0.dynamic_pcell$5_0.G_DRN.n14 0.0168263
R10927 ota_cmfb_top_0.dynamic_pcell$5_0.G_DRN ota_cmfb_top_0.dynamic_pcell$5_0.G_DRN.n15 0.0125004
R10928 ota_cmfb_top_0.dynamic_pcell$5_0.G_DRN ota_cmfb_top_0.dynamic_pcell$5_0.G_DRN.n17 0.0125004
R10929 ota_cmfb_top_0.dynamic_pcell$5_0.G_DRN ota_cmfb_top_0.dynamic_pcell$5_0.G_DRN.n19 0.0125004
R10930 ota_cmfb_top_0.dynamic_pcell$5_0.G_DRN ota_cmfb_top_0.dynamic_pcell$5_0.G_DRN.n21 0.0100317
R10931 ota_cmfb_top_0.dynamic_pcell$5_0.G_DRN ota_cmfb_top_0.dynamic_pcell$5_0.G_DRN.n32 3.9341
R10932 ota_cmfb_top_0.dynamic_pcell$5_0.G_DRN.n47 ota_cmfb_top_0.dynamic_pcell$5_0.G_DRN.n16 3.84101
R10933 ota_cmfb_top_0.dynamic_pcell$5_0.G_DRN.n18 ota_cmfb_top_0.dynamic_pcell$5_0.G_DRN 3.51981
R10934 ota_cmfb_top_0.dynamic_pcell$5_0.G_DRN.n22 ota_cmfb_top_0.dynamic_pcell$5_0.G_DRN 3.51612
R10935 ota_cmfb_top_0.dynamic_pcell$5_0.G_DRN ota_cmfb_top_0.dynamic_pcell$5_0.G_DRN.n16 0.0125004
R10936 ota_cmfb_top_0.dynamic_pcell$5_0.G_DRN ota_cmfb_top_0.dynamic_pcell$5_0.G_DRN.n18 0.0125004
R10937 ota_cmfb_top_0.dynamic_pcell$5_0.G_DRN ota_cmfb_top_0.dynamic_pcell$5_0.G_DRN.n20 0.0125004
R10938 ota_cmfb_top_0.dynamic_pcell$5_0.G_DRN ota_cmfb_top_0.dynamic_pcell$5_0.G_DRN.n22 0.0100317
R10939 ota_cmfb_top_0.dynamic_pcell$5_0.G_DRN ota_cmfb_top_0.dynamic_pcell$5_0.G_DRN.n58 3.0445
R10940 ota_cmfb_top_0.dynamic_pcell$5_0.G_DRN.n51 ota_cmfb_top_0.dynamic_pcell$5_0.G_DRN.n15 3.0182
R10941 ota_cmfb_top_0.dynamic_pcell$5_0.G_DRN.n53 ota_cmfb_top_0.dynamic_pcell$5_0.G_DRN.n17 3.0182
R10942 ota_cmfb_top_0.dynamic_pcell$5_0.G_DRN.n20 ota_cmfb_top_0.dynamic_pcell$5_0.G_DRN.n26 3.0182
R10943 ota_cmfb_top_0.dynamic_pcell$5_0.G_DRN.n31 ota_cmfb_top_0.dynamic_pcell$5_0.G_DRN.n19 3.0182
R10944 ota_cmfb_top_0.dynamic_pcell$5_0.G_DRN.n32 ota_cmfb_top_0.dynamic_pcell$5_0.G_DRN.n21 3.01452
R10945 ota_cmfb_top_0.dynamic_pcell$5_0.G_DRN.n43 ota_cmfb_top_0.dynamic_pcell$5_0.G_DRN.n14 3.02465
R10946 ota_cmfb_top_0.dynamic_pcell$5_0.G_DRN.n55 ota_cmfb_top_0.dynamic_pcell$5_0.G_DRN.n54 2.95639
R10947 ota_cmfb_top_0.dynamic_pcell$5_0.G_DRN.n44 ota_cmfb_top_0.dynamic_pcell$5_0.G_DRN.n33 2.95639
R10948 ota_cmfb_top_0.dynamic_pcell$5_0.G_DRN.n54 ota_cmfb_top_0.dynamic_pcell$5_0.G_DRN.n52 2.55159
R10949 ota_cmfb_top_0.dynamic_pcell$5_0.G_DRN ota_cmfb_top_0.dynamic_pcell$5_0.G_DRN.n11 2.03698
R10950 ota_cmfb_top_0.dynamic_pcell$5_0.G_DRN ota_cmfb_top_0.dynamic_pcell$5_0.G_DRN.n13 2.03698
R10951 ota_cmfb_top_0.dynamic_pcell$5_0.G_DRN.n61 ota_cmfb_top_0.dynamic_pcell$5_0.G_DRN 1.68733
R10952 ota_cmfb_top_0.dynamic_pcell$5_0.G_DRN.n60 ota_cmfb_top_0.dynamic_pcell$5_0.G_DRN 1.68733
R10953 ota_cmfb_top_0.dynamic_pcell$5_0.G_DRN.n23 ota_cmfb_top_0.dynamic_pcell$5_0.G_DRN 1.68733
R10954 ota_cmfb_top_0.dynamic_pcell$5_0.G_DRN.n56 ota_cmfb_top_0.dynamic_pcell$5_0.G_DRN 1.68722
R10955 ota_cmfb_top_0.dynamic_pcell$5_0.G_DRN.n23 ota_cmfb_top_0.dynamic_pcell$5_0.G_DRN.n56 1.44547
R10956 ota_cmfb_top_0.dynamic_pcell$5_0.G_DRN.n61 ota_cmfb_top_0.dynamic_pcell$5_0.G_DRN.n60 1.44482
R10957 ota_cmfb_top_0.dynamic_pcell$5_0.G_DRN ota_cmfb_top_0.dynamic_pcell$5_0.G_DRN.n44 1.07364
R10958 ota_cmfb_top_0.dynamic_pcell$5_0.G_DRN.n55 ota_cmfb_top_0.dynamic_pcell$5_0.G_DRN 0.871245
R10959 ota_cmfb_top_0.dynamic_pcell$5_0.G_DRN ota_cmfb_top_0.dynamic_pcell$5_0.G_DRN.n53 0.8365
R10960 ota_cmfb_top_0.dynamic_pcell$5_0.G_DRN.n51 ota_cmfb_top_0.dynamic_pcell$5_0.G_DRN.n10 0.928175
R10961 ota_cmfb_top_0.dynamic_pcell$5_0.G_DRN.n27 ota_cmfb_top_0.dynamic_pcell$5_0.G_DRN.n26 0.8233
R10962 ota_cmfb_top_0.dynamic_pcell$5_0.G_DRN.n31 ota_cmfb_top_0.dynamic_pcell$5_0.G_DRN.n12 0.928175
R10963 ota_cmfb_top_0.dynamic_pcell$5_0.G_DRN.n60 ota_cmfb_top_0.dynamic_pcell$5_0.G_DRN.n59 0.72332
R10964 ota_cmfb_top_0.dynamic_pcell$5_0.G_DRN.n57 ota_cmfb_top_0.dynamic_pcell$5_0.G_DRN.n56 0.722599
R10965 ota_cmfb_top_0.dynamic_pcell$5_0.G_DRN.n23 ota_cmfb_top_0.dynamic_pcell$5_0.G_DRN.n59 0.722001
R10966 ota_cmfb_top_0.dynamic_pcell$5_0.G_DRN.n6 ota_cmfb_top_0.dynamic_pcell$5_0.G_DRN.n5 0.747775
R10967 ota_cmfb_top_0.dynamic_pcell$5_0.G_DRN.n50 ota_cmfb_top_0.dynamic_pcell$5_0.G_DRN 0.5945
R10968 ota_cmfb_top_0.dynamic_pcell$5_0.G_DRN.n30 ota_cmfb_top_0.dynamic_pcell$5_0.G_DRN 0.5945
R10969 ota_cmfb_top_0.dynamic_pcell$5_0.G_DRN.n58 ota_cmfb_top_0.dynamic_pcell$5_0.G_DRN.n57 0.5021
R10970 ota_cmfb_top_0.dynamic_pcell$5_0.G_DRN.n53 ota_cmfb_top_0.dynamic_pcell$5_0.G_DRN 0.5021
R10971 ota_cmfb_top_0.dynamic_pcell$5_0.G_DRN.n32 ota_cmfb_top_0.dynamic_pcell$5_0.G_DRN 0.5021
R10972 ota_cmfb_top_0.dynamic_pcell$5_0.G_DRN.n43 ota_cmfb_top_0.dynamic_pcell$5_0.G_DRN.n34 0.5021
R10973 ota_cmfb_top_0.dynamic_pcell$5_0.G_DRN ota_cmfb_top_0.dynamic_pcell$5_0.G_DRN.t0 5.55211
R10974 ota_cmfb_top_0.dynamic_pcell$5_0.G_DRN ota_cmfb_top_0.dynamic_pcell$5_0.G_DRN.n3 3.03363
R10975 ota_cmfb_top_0.dynamic_pcell$5_0.G_DRN ota_cmfb_top_0.dynamic_pcell$5_0.G_DRN.n1 3.03363
R10976 ota_cmfb_top_0.dynamic_pcell$5_0.G_DRN.n8 ota_cmfb_top_0.dynamic_pcell$5_0.G_DRN.n38 0.426575
R10977 ota_cmfb_top_0.dynamic_pcell$5_0.G_DRN.n38 ota_cmfb_top_0.dynamic_pcell$5_0.G_DRN.n36 0.3217
R10978 ota_cmfb_top_0.dynamic_pcell$5_0.G_DRN.n37 ota_cmfb_top_0.dynamic_pcell$5_0.G_DRN.n36 0.2117
R10979 ota_cmfb_top_0.dynamic_pcell$5_0.G_DRN.n48 ota_cmfb_top_0.dynamic_pcell$5_0.G_DRN.n47 0.2117
R10980 ota_cmfb_top_0.dynamic_pcell$5_0.G_DRN.n49 ota_cmfb_top_0.dynamic_pcell$5_0.G_DRN.n48 0.2117
R10981 ota_cmfb_top_0.dynamic_pcell$5_0.G_DRN.n49 ota_cmfb_top_0.dynamic_pcell$5_0.G_DRN.n11 0.316575
R10982 ota_cmfb_top_0.dynamic_pcell$5_0.G_DRN.n50 ota_cmfb_top_0.dynamic_pcell$5_0.G_DRN.n46 0.2117
R10983 ota_cmfb_top_0.dynamic_pcell$5_0.G_DRN.n46 ota_cmfb_top_0.dynamic_pcell$5_0.G_DRN.n45 0.2117
R10984 ota_cmfb_top_0.dynamic_pcell$5_0.G_DRN.n45 ota_cmfb_top_0.dynamic_pcell$5_0.G_DRN.n10 0.316575
R10985 ota_cmfb_top_0.dynamic_pcell$5_0.G_DRN.n28 ota_cmfb_top_0.dynamic_pcell$5_0.G_DRN.n27 0.2117
R10986 ota_cmfb_top_0.dynamic_pcell$5_0.G_DRN.n29 ota_cmfb_top_0.dynamic_pcell$5_0.G_DRN.n28 0.2117
R10987 ota_cmfb_top_0.dynamic_pcell$5_0.G_DRN.n29 ota_cmfb_top_0.dynamic_pcell$5_0.G_DRN.n13 0.316575
R10988 ota_cmfb_top_0.dynamic_pcell$5_0.G_DRN.n30 ota_cmfb_top_0.dynamic_pcell$5_0.G_DRN.n25 0.2117
R10989 ota_cmfb_top_0.dynamic_pcell$5_0.G_DRN.n25 ota_cmfb_top_0.dynamic_pcell$5_0.G_DRN.n24 0.2117
R10990 ota_cmfb_top_0.dynamic_pcell$5_0.G_DRN.n24 ota_cmfb_top_0.dynamic_pcell$5_0.G_DRN.n12 0.316575
R10991 ota_cmfb_top_0.dynamic_pcell$5_0.G_DRN.n42 ota_cmfb_top_0.dynamic_pcell$5_0.G_DRN.n41 0.2117
R10992 ota_cmfb_top_0.dynamic_pcell$5_0.G_DRN.n42 ota_cmfb_top_0.dynamic_pcell$5_0.G_DRN.n40 0.2117
R10993 ota_cmfb_top_0.dynamic_pcell$5_0.G_DRN.n40 ota_cmfb_top_0.dynamic_pcell$5_0.G_DRN.n6 0.316575
R10994 ota_cmfb_top_0.dynamic_pcell$5_0.G_DRN.n5 ota_cmfb_top_0.dynamic_pcell$5_0.G_DRN.n7 0.2117
R10995 ota_cmfb_top_0.dynamic_pcell$5_0.G_DRN.n39 ota_cmfb_top_0.dynamic_pcell$5_0.G_DRN.n7 0.2117
R10996 ota_cmfb_top_0.dynamic_pcell$5_0.G_DRN.n39 ota_cmfb_top_0.dynamic_pcell$5_0.G_DRN.n8 0.316575
R10997 ota_cmfb_top_0.dynamic_pcell$5_0.G_DRN.n37 ota_cmfb_top_0.dynamic_pcell$5_0.G_DRN.n35 0.2117
R10998 ota_cmfb_top_0.dynamic_pcell$5_0.G_DRN.n35 ota_cmfb_top_0.dynamic_pcell$5_0.G_DRN.n9 0.316575
R10999 ota_cmfb_top_0.dynamic_pcell$5_0.G_DRN.n9 ota_cmfb_top_0.dynamic_pcell$5_0.G_DRN.n0 1.20015
R11000 ota_cmfb_top_0.dynamic_pcell$5_0.DRN_NET_JL.n30 ota_cmfb_top_0.dynamic_pcell$5_0.DRN_NET_JL.t2 48.2357
R11001 ota_cmfb_top_0.dynamic_pcell$5_0.DRN_NET_JL ota_cmfb_top_0.dynamic_pcell$5_0.DRN_NET_JL.t4 26.2926
R11002 ota_cmfb_top_0.dynamic_pcell$5_0.DRN_NET_JL ota_cmfb_top_0.dynamic_pcell$5_0.DRN_NET_JL.t3 26.2926
R11003 ota_cmfb_top_0.dynamic_pcell$5_0.DRN_NET_JL.n31 ota_cmfb_top_0.dynamic_pcell$5_0.DRN_NET_JL 25.9506
R11004 ota_cmfb_top_0.dynamic_pcell$5_0.DRN_NET_JL ota_cmfb_top_0.dynamic_pcell$5_0.DRN_NET_JL.n32 22.6154
R11005 ota_cmfb_top_0.dynamic_pcell$5_0.DRN_NET_JL.n31 ota_cmfb_top_0.dynamic_pcell$5_0.DRN_NET_JL 16.6807
R11006 ota_cmfb_top_0.dynamic_pcell$5_0.DRN_NET_JL ota_cmfb_top_0.dynamic_pcell$5_0.DRN_NET_JL.n3 1.62395
R11007 ota_cmfb_top_0.dynamic_pcell$5_0.DRN_NET_JL ota_cmfb_top_0.dynamic_pcell$5_0.DRN_NET_JL.n2 1.96988
R11008 ota_cmfb_top_0.dynamic_pcell$5_0.DRN_NET_JL ota_cmfb_top_0.dynamic_pcell$5_0.DRN_NET_JL.n5 1.62395
R11009 ota_cmfb_top_0.dynamic_pcell$5_0.DRN_NET_JL ota_cmfb_top_0.dynamic_pcell$5_0.DRN_NET_JL.n0 1.96988
R11010 ota_cmfb_top_0.dynamic_pcell$5_0.DRN_NET_JL ota_cmfb_top_0.dynamic_pcell$5_0.DRN_NET_JL.n7 1.62395
R11011 ota_cmfb_top_0.dynamic_pcell$5_0.DRN_NET_JL ota_cmfb_top_0.dynamic_pcell$5_0.DRN_NET_JL.n1 1.96988
R11012 ota_cmfb_top_0.dynamic_pcell$5_0.DRN_NET_JL ota_cmfb_top_0.dynamic_pcell$5_0.DRN_NET_JL.n9 2.94552
R11013 ota_cmfb_top_0.dynamic_pcell$5_0.DRN_NET_JL.n32 ota_cmfb_top_0.dynamic_pcell$5_0.DRN_NET_JL 10.2875
R11014 ota_cmfb_top_0.dynamic_pcell$5_0.DRN_NET_JL ota_cmfb_top_0.dynamic_pcell$5_0.DRN_NET_JL.n33 10.2518
R11015 ota_cmfb_top_0.dynamic_pcell$5_0.DRN_NET_JL.n30 ota_cmfb_top_0.dynamic_pcell$5_0.DRN_NET_JL.n29 9.51659
R11016 ota_cmfb_top_0.dynamic_pcell$5_0.DRN_NET_JL.n22 ota_cmfb_top_0.dynamic_pcell$5_0.DRN_NET_JL 2.90958
R11017 ota_cmfb_top_0.dynamic_pcell$5_0.DRN_NET_JL ota_cmfb_top_0.dynamic_pcell$5_0.DRN_NET_JL.n11 2.12467
R11018 ota_cmfb_top_0.dynamic_pcell$5_0.DRN_NET_JL ota_cmfb_top_0.dynamic_pcell$5_0.DRN_NET_JL.n3 1.34641
R11019 ota_cmfb_top_0.dynamic_pcell$5_0.DRN_NET_JL.n4 ota_cmfb_top_0.dynamic_pcell$5_0.DRN_NET_JL.n3 0.917799
R11020 ota_cmfb_top_0.dynamic_pcell$5_0.DRN_NET_JL ota_cmfb_top_0.dynamic_pcell$5_0.DRN_NET_JL.n4 1.5277
R11021 ota_cmfb_top_0.dynamic_pcell$5_0.DRN_NET_JL ota_cmfb_top_0.dynamic_pcell$5_0.DRN_NET_JL.n2 0.504353
R11022 ota_cmfb_top_0.dynamic_pcell$5_0.DRN_NET_JL.n21 ota_cmfb_top_0.dynamic_pcell$5_0.DRN_NET_JL 2.90958
R11023 ota_cmfb_top_0.dynamic_pcell$5_0.DRN_NET_JL ota_cmfb_top_0.dynamic_pcell$5_0.DRN_NET_JL.n13 2.12467
R11024 ota_cmfb_top_0.dynamic_pcell$5_0.DRN_NET_JL ota_cmfb_top_0.dynamic_pcell$5_0.DRN_NET_JL.n5 1.34641
R11025 ota_cmfb_top_0.dynamic_pcell$5_0.DRN_NET_JL.n6 ota_cmfb_top_0.dynamic_pcell$5_0.DRN_NET_JL.n5 0.917799
R11026 ota_cmfb_top_0.dynamic_pcell$5_0.DRN_NET_JL ota_cmfb_top_0.dynamic_pcell$5_0.DRN_NET_JL.n6 1.5277
R11027 ota_cmfb_top_0.dynamic_pcell$5_0.DRN_NET_JL ota_cmfb_top_0.dynamic_pcell$5_0.DRN_NET_JL.n0 0.504353
R11028 ota_cmfb_top_0.dynamic_pcell$5_0.DRN_NET_JL.n20 ota_cmfb_top_0.dynamic_pcell$5_0.DRN_NET_JL 2.90958
R11029 ota_cmfb_top_0.dynamic_pcell$5_0.DRN_NET_JL ota_cmfb_top_0.dynamic_pcell$5_0.DRN_NET_JL.n15 2.12467
R11030 ota_cmfb_top_0.dynamic_pcell$5_0.DRN_NET_JL ota_cmfb_top_0.dynamic_pcell$5_0.DRN_NET_JL.n7 1.34641
R11031 ota_cmfb_top_0.dynamic_pcell$5_0.DRN_NET_JL.n8 ota_cmfb_top_0.dynamic_pcell$5_0.DRN_NET_JL.n7 0.917799
R11032 ota_cmfb_top_0.dynamic_pcell$5_0.DRN_NET_JL ota_cmfb_top_0.dynamic_pcell$5_0.DRN_NET_JL.n8 1.5277
R11033 ota_cmfb_top_0.dynamic_pcell$5_0.DRN_NET_JL ota_cmfb_top_0.dynamic_pcell$5_0.DRN_NET_JL.n1 0.504353
R11034 ota_cmfb_top_0.dynamic_pcell$5_0.DRN_NET_JL.n25 ota_cmfb_top_0.dynamic_pcell$5_0.DRN_NET_JL 3.12758
R11035 ota_cmfb_top_0.dynamic_pcell$5_0.DRN_NET_JL ota_cmfb_top_0.dynamic_pcell$5_0.DRN_NET_JL.n23 2.12467
R11036 ota_cmfb_top_0.dynamic_pcell$5_0.DRN_NET_JL.n26 ota_cmfb_top_0.dynamic_pcell$5_0.DRN_NET_JL 2.90958
R11037 ota_cmfb_top_0.dynamic_pcell$5_0.DRN_NET_JL ota_cmfb_top_0.dynamic_pcell$5_0.DRN_NET_JL.n9 2.33345
R11038 ota_cmfb_top_0.dynamic_pcell$5_0.DRN_NET_JL.n10 ota_cmfb_top_0.dynamic_pcell$5_0.DRN_NET_JL.n9 0.890266
R11039 ota_cmfb_top_0.dynamic_pcell$5_0.DRN_NET_JL ota_cmfb_top_0.dynamic_pcell$5_0.DRN_NET_JL.n4 2.14369
R11040 ota_cmfb_top_0.dynamic_pcell$5_0.DRN_NET_JL ota_cmfb_top_0.dynamic_pcell$5_0.DRN_NET_JL.n2 2.59534
R11041 ota_cmfb_top_0.dynamic_pcell$5_0.DRN_NET_JL ota_cmfb_top_0.dynamic_pcell$5_0.DRN_NET_JL.n6 2.14369
R11042 ota_cmfb_top_0.dynamic_pcell$5_0.DRN_NET_JL ota_cmfb_top_0.dynamic_pcell$5_0.DRN_NET_JL.n0 2.59534
R11043 ota_cmfb_top_0.dynamic_pcell$5_0.DRN_NET_JL ota_cmfb_top_0.dynamic_pcell$5_0.DRN_NET_JL.n8 2.14369
R11044 ota_cmfb_top_0.dynamic_pcell$5_0.DRN_NET_JL ota_cmfb_top_0.dynamic_pcell$5_0.DRN_NET_JL.n1 2.59534
R11045 ota_cmfb_top_0.dynamic_pcell$5_0.DRN_NET_JL ota_cmfb_top_0.dynamic_pcell$5_0.DRN_NET_JL.n10 1.35184
R11046 ota_cmfb_top_0.dynamic_pcell$5_0.DRN_NET_JL ota_cmfb_top_0.dynamic_pcell$5_0.DRN_NET_JL.t1 5.19019
R11047 ota_cmfb_top_0.dynamic_pcell$5_0.DRN_NET_JL.n32 ota_cmfb_top_0.dynamic_pcell$5_0.DRN_NET_JL 4.41984
R11048 ota_cmfb_top_0.dynamic_pcell$5_0.DRN_NET_JL.n33 ota_cmfb_top_0.dynamic_pcell$5_0.DRN_NET_JL 3.5051
R11049 ota_cmfb_top_0.dynamic_pcell$5_0.DRN_NET_JL.n29 ota_cmfb_top_0.dynamic_pcell$5_0.DRN_NET_JL.n28 2.82439
R11050 ota_cmfb_top_0.dynamic_pcell$5_0.DRN_NET_JL.n33 ota_cmfb_top_0.dynamic_pcell$5_0.DRN_NET_JL.n30 1.4173
R11051 ota_cmfb_top_0.dynamic_pcell$5_0.DRN_NET_JL ota_cmfb_top_0.dynamic_pcell$5_0.DRN_NET_JL.n27 1.41244
R11052 ota_cmfb_top_0.dynamic_pcell$5_0.DRN_NET_JL.n12 ota_cmfb_top_0.dynamic_pcell$5_0.DRN_NET_JL 1.50709
R11053 ota_cmfb_top_0.dynamic_pcell$5_0.DRN_NET_JL.n14 ota_cmfb_top_0.dynamic_pcell$5_0.DRN_NET_JL 1.50709
R11054 ota_cmfb_top_0.dynamic_pcell$5_0.DRN_NET_JL.n16 ota_cmfb_top_0.dynamic_pcell$5_0.DRN_NET_JL 1.50709
R11055 ota_cmfb_top_0.dynamic_pcell$5_0.DRN_NET_JL.n24 ota_cmfb_top_0.dynamic_pcell$5_0.DRN_NET_JL 1.50709
R11056 ota_cmfb_top_0.dynamic_pcell$5_0.DRN_NET_JL.n28 ota_cmfb_top_0.dynamic_pcell$5_0.DRN_NET_JL 1.00764
R11057 ota_cmfb_top_0.dynamic_pcell$5_0.DRN_NET_JL ota_cmfb_top_0.dynamic_pcell$5_0.DRN_NET_JL.n31 0.668845
R11058 ota_cmfb_top_0.dynamic_pcell$5_0.DRN_NET_JL ota_cmfb_top_0.dynamic_pcell$5_0.DRN_NET_JL.t0 5.75451
R11059 ota_cmfb_top_0.dynamic_pcell$5_0.DRN_NET_JL.n27 ota_cmfb_top_0.dynamic_pcell$5_0.DRN_NET_JL.n22 14.17
R11060 ota_cmfb_top_0.dynamic_pcell$5_0.DRN_NET_JL.n11 ota_cmfb_top_0.dynamic_pcell$5_0.DRN_NET_JL.n22 0.725565
R11061 ota_cmfb_top_0.dynamic_pcell$5_0.DRN_NET_JL.n11 ota_cmfb_top_0.dynamic_pcell$5_0.DRN_NET_JL.n12 1.00864
R11062 ota_cmfb_top_0.dynamic_pcell$5_0.DRN_NET_JL ota_cmfb_top_0.dynamic_pcell$5_0.DRN_NET_JL.n19 1.50709
R11063 ota_cmfb_top_0.dynamic_pcell$5_0.DRN_NET_JL.n19 ota_cmfb_top_0.dynamic_pcell$5_0.DRN_NET_JL 2.29577
R11064 ota_cmfb_top_0.dynamic_pcell$5_0.DRN_NET_JL.n27 ota_cmfb_top_0.dynamic_pcell$5_0.DRN_NET_JL.n21 11.7509
R11065 ota_cmfb_top_0.dynamic_pcell$5_0.DRN_NET_JL.n13 ota_cmfb_top_0.dynamic_pcell$5_0.DRN_NET_JL.n21 0.725565
R11066 ota_cmfb_top_0.dynamic_pcell$5_0.DRN_NET_JL.n13 ota_cmfb_top_0.dynamic_pcell$5_0.DRN_NET_JL.n14 1.00864
R11067 ota_cmfb_top_0.dynamic_pcell$5_0.DRN_NET_JL ota_cmfb_top_0.dynamic_pcell$5_0.DRN_NET_JL.n18 1.50709
R11068 ota_cmfb_top_0.dynamic_pcell$5_0.DRN_NET_JL.n18 ota_cmfb_top_0.dynamic_pcell$5_0.DRN_NET_JL 2.29577
R11069 ota_cmfb_top_0.dynamic_pcell$5_0.DRN_NET_JL.n28 ota_cmfb_top_0.dynamic_pcell$5_0.DRN_NET_JL.n20 11.7509
R11070 ota_cmfb_top_0.dynamic_pcell$5_0.DRN_NET_JL.n15 ota_cmfb_top_0.dynamic_pcell$5_0.DRN_NET_JL.n20 0.725565
R11071 ota_cmfb_top_0.dynamic_pcell$5_0.DRN_NET_JL.n15 ota_cmfb_top_0.dynamic_pcell$5_0.DRN_NET_JL.n16 1.00864
R11072 ota_cmfb_top_0.dynamic_pcell$5_0.DRN_NET_JL ota_cmfb_top_0.dynamic_pcell$5_0.DRN_NET_JL.n17 1.50709
R11073 ota_cmfb_top_0.dynamic_pcell$5_0.DRN_NET_JL.n17 ota_cmfb_top_0.dynamic_pcell$5_0.DRN_NET_JL 2.29577
R11074 ota_cmfb_top_0.dynamic_pcell$5_0.DRN_NET_JL.n29 ota_cmfb_top_0.dynamic_pcell$5_0.DRN_NET_JL.n25 11.7509
R11075 ota_cmfb_top_0.dynamic_pcell$5_0.DRN_NET_JL.n16 ota_cmfb_top_0.dynamic_pcell$5_0.DRN_NET_JL 1.95065
R11076 ota_cmfb_top_0.dynamic_pcell$5_0.DRN_NET_JL.n14 ota_cmfb_top_0.dynamic_pcell$5_0.DRN_NET_JL 1.95065
R11077 ota_cmfb_top_0.dynamic_pcell$5_0.DRN_NET_JL.n12 ota_cmfb_top_0.dynamic_pcell$5_0.DRN_NET_JL 1.95065
R11078 ota_cmfb_top_0.dynamic_pcell$5_0.DRN_NET_JL.n23 ota_cmfb_top_0.dynamic_pcell$5_0.DRN_NET_JL.n25 0.725565
R11079 ota_cmfb_top_0.dynamic_pcell$5_0.DRN_NET_JL.n23 ota_cmfb_top_0.dynamic_pcell$5_0.DRN_NET_JL.n24 1.00864
R11080 ota_cmfb_top_0.dynamic_pcell$5_0.DRN_NET_JL ota_cmfb_top_0.dynamic_pcell$5_0.DRN_NET_JL.n26 1.22407
R11081 ota_cmfb_top_0.dynamic_pcell$5_0.DRN_NET_JL.n26 ota_cmfb_top_0.dynamic_pcell$5_0.DRN_NET_JL 1.79511
R11082 ota_cmfb_top_0.dynamic_pcell$5_0.DRN_NET_JL ota_cmfb_top_0.dynamic_pcell$5_0.DRN_NET_JL.n10 1.12659
R11083 ota_cmfb_top_0.dynamic_pcell$5_0.DRN_NET_JL.n19 ota_cmfb_top_0.dynamic_pcell$5_0.DRN_NET_JL 1.81508
R11084 ota_cmfb_top_0.dynamic_pcell$5_0.DRN_NET_JL.n18 ota_cmfb_top_0.dynamic_pcell$5_0.DRN_NET_JL 1.81508
R11085 ota_cmfb_top_0.dynamic_pcell$5_0.DRN_NET_JL.n17 ota_cmfb_top_0.dynamic_pcell$5_0.DRN_NET_JL 1.81508
R11086 ota_cmfb_top_0.dynamic_pcell$5_0.DRN_NET_JL.n24 ota_cmfb_top_0.dynamic_pcell$5_0.DRN_NET_JL 1.38088
R11087 ota_cmfb_top_0.dynamic_pcell$5_0.SRC_NET_KL.n7 ota_cmfb_top_0.dynamic_pcell$5_0.SRC_NET_KL 12.5887
R11088 ota_cmfb_top_0.dynamic_pcell$5_0.SRC_NET_KL.n6 ota_cmfb_top_0.dynamic_pcell$5_0.SRC_NET_KL.n3 11.4746
R11089 ota_cmfb_top_0.dynamic_pcell$5_0.SRC_NET_KL ota_cmfb_top_0.dynamic_pcell$5_0.SRC_NET_KL.t7 10.5943
R11090 ota_cmfb_top_0.dynamic_pcell$5_0.SRC_NET_KL ota_cmfb_top_0.dynamic_pcell$5_0.SRC_NET_KL.t6 10.5943
R11091 ota_cmfb_top_0.dynamic_pcell$5_0.SRC_NET_KL ota_cmfb_top_0.dynamic_pcell$5_0.SRC_NET_KL.t5 10.4931
R11092 ota_cmfb_top_0.dynamic_pcell$5_0.SRC_NET_KL ota_cmfb_top_0.dynamic_pcell$5_0.SRC_NET_KL.t4 10.4931
R11093 ota_cmfb_top_0.dynamic_pcell$5_0.SRC_NET_KL ota_cmfb_top_0.dynamic_pcell$5_0.SRC_NET_KL.n3 9.83384
R11094 ota_cmfb_top_0.dynamic_pcell$5_0.SRC_NET_KL.n5 ota_cmfb_top_0.dynamic_pcell$5_0.SRC_NET_KL 9.83384
R11095 ota_cmfb_top_0.dynamic_pcell$5_0.SRC_NET_KL.n6 ota_cmfb_top_0.dynamic_pcell$5_0.SRC_NET_KL.n5 9.8079
R11096 ota_cmfb_top_0.dynamic_pcell$5_0.SRC_NET_KL.n4 ota_cmfb_top_0.dynamic_pcell$5_0.SRC_NET_KL 9.60064
R11097 ota_cmfb_top_0.dynamic_pcell$5_0.SRC_NET_KL.n1 ota_cmfb_top_0.dynamic_pcell$5_0.SRC_NET_KL 9.78888
R11098 ota_cmfb_top_0.dynamic_pcell$5_0.SRC_NET_KL.n2 ota_cmfb_top_0.dynamic_pcell$5_0.SRC_NET_KL 9.49944
R11099 ota_cmfb_top_0.dynamic_pcell$5_0.SRC_NET_KL.t2 ota_cmfb_top_0.dynamic_pcell$5_0.SRC_NET_KL.n0 4.99669
R11100 ota_cmfb_top_0.dynamic_pcell$5_0.SRC_NET_KL.t1 ota_cmfb_top_0.dynamic_pcell$5_0.SRC_NET_KL.n1 4.99669
R11101 ota_cmfb_top_0.dynamic_pcell$5_0.SRC_NET_KL.n5 ota_cmfb_top_0.dynamic_pcell$5_0.SRC_NET_KL 6.8623
R11102 ota_cmfb_top_0.dynamic_pcell$5_0.SRC_NET_KL ota_cmfb_top_0.dynamic_pcell$5_0.SRC_NET_KL.t0 6.37534
R11103 ota_cmfb_top_0.dynamic_pcell$5_0.SRC_NET_KL.n3 ota_cmfb_top_0.dynamic_pcell$5_0.SRC_NET_KL 5.6787
R11104 ota_cmfb_top_0.dynamic_pcell$5_0.SRC_NET_KL ota_cmfb_top_0.dynamic_pcell$5_0.SRC_NET_KL.n7 3.46724
R11105 ota_cmfb_top_0.dynamic_pcell$5_0.SRC_NET_KL.n2 ota_cmfb_top_0.dynamic_pcell$5_0.SRC_NET_KL 2.3677
R11106 ota_cmfb_top_0.dynamic_pcell$5_0.SRC_NET_KL.n4 ota_cmfb_top_0.dynamic_pcell$5_0.SRC_NET_KL 2.3677
R11107 ota_cmfb_top_0.dynamic_pcell$5_0.SRC_NET_KL ota_cmfb_top_0.dynamic_pcell$5_0.SRC_NET_KL.n4 2.1279
R11108 ota_cmfb_top_0.dynamic_pcell$5_0.SRC_NET_KL.n7 ota_cmfb_top_0.dynamic_pcell$5_0.SRC_NET_KL.n6 2.04559
R11109 ota_cmfb_top_0.dynamic_pcell$5_0.SRC_NET_KL ota_cmfb_top_0.dynamic_pcell$5_0.SRC_NET_KL.t3 6.37271
R11110 ota_cmfb_top_0.dynamic_pcell$5_0.SRC_NET_KL ota_cmfb_top_0.dynamic_pcell$5_0.SRC_NET_KL.n2 0.9443
R11111 ota_cmfb_top_0.dynamic_pcell$5_0.SRC_NET_KL ota_cmfb_top_0.dynamic_pcell$5_0.SRC_NET_KL.n0 0.65074
R11112 ota_cmfb_top_0.dynamic_pcell$5_0.SRC_NET_KL ota_cmfb_top_0.dynamic_pcell$5_0.SRC_NET_KL.n1 1.37323
R11113 ota_cmfb_top_0.dynamic_pcell$5_0.SRC_NET_KL ota_cmfb_top_0.dynamic_pcell$5_0.SRC_NET_KL.n0 1.37323
R11114 ota_cmfb_top_0.dynamic_pcell$5_0.H_DRN.n15 ota_cmfb_top_0.dynamic_pcell$5_0.H_DRN.t6 48.9585
R11115 ota_cmfb_top_0.dynamic_pcell$5_0.H_DRN ota_cmfb_top_0.dynamic_pcell$5_0.H_DRN.t2 26.3938
R11116 ota_cmfb_top_0.dynamic_pcell$5_0.H_DRN ota_cmfb_top_0.dynamic_pcell$5_0.H_DRN.t3 26.1914
R11117 ota_cmfb_top_0.dynamic_pcell$5_0.H_DRN.n19 ota_cmfb_top_0.dynamic_pcell$5_0.H_DRN.n18 23.049
R11118 ota_cmfb_top_0.dynamic_pcell$5_0.H_DRN.n18 ota_cmfb_top_0.dynamic_pcell$5_0.H_DRN 20.3943
R11119 ota_cmfb_top_0.dynamic_pcell$5_0.H_DRN ota_cmfb_top_0.dynamic_pcell$5_0.H_DRN.n8 5.29701
R11120 ota_cmfb_top_0.dynamic_pcell$5_0.H_DRN ota_cmfb_top_0.dynamic_pcell$5_0.H_DRN.n6 5.29701
R11121 ota_cmfb_top_0.dynamic_pcell$5_0.H_DRN ota_cmfb_top_0.dynamic_pcell$5_0.H_DRN.n4 5.29701
R11122 ota_cmfb_top_0.dynamic_pcell$5_0.H_DRN ota_cmfb_top_0.dynamic_pcell$5_0.H_DRN.n21 15.0005
R11123 ota_cmfb_top_0.dynamic_pcell$5_0.H_DRN.n23 ota_cmfb_top_0.dynamic_pcell$5_0.H_DRN.n19 13.706
R11124 ota_cmfb_top_0.dynamic_pcell$5_0.H_DRN.n24 ota_cmfb_top_0.dynamic_pcell$5_0.H_DRN.n19 11.6339
R11125 ota_cmfb_top_0.dynamic_pcell$5_0.H_DRN ota_cmfb_top_0.dynamic_pcell$5_0.H_DRN.t0 10.5943
R11126 ota_cmfb_top_0.dynamic_pcell$5_0.H_DRN ota_cmfb_top_0.dynamic_pcell$5_0.H_DRN.t1 10.4931
R11127 ota_cmfb_top_0.dynamic_pcell$5_0.H_DRN.n0 ota_cmfb_top_0.dynamic_pcell$5_0.H_DRN 10.3611
R11128 ota_cmfb_top_0.dynamic_pcell$5_0.H_DRN.n24 ota_cmfb_top_0.dynamic_pcell$5_0.H_DRN 10.0362
R11129 ota_cmfb_top_0.dynamic_pcell$5_0.H_DRN ota_cmfb_top_0.dynamic_pcell$5_0.H_DRN.n23 10.0362
R11130 ota_cmfb_top_0.dynamic_pcell$5_0.H_DRN ota_cmfb_top_0.dynamic_pcell$5_0.H_DRN.n25 9.49945
R11131 ota_cmfb_top_0.dynamic_pcell$5_0.H_DRN ota_cmfb_top_0.dynamic_pcell$5_0.H_DRN.n17 9.0005
R11132 ota_cmfb_top_0.dynamic_pcell$5_0.H_DRN.t5 ota_cmfb_top_0.dynamic_pcell$5_0.H_DRN.n9 4.69774
R11133 ota_cmfb_top_0.dynamic_pcell$5_0.H_DRN.n1 ota_cmfb_top_0.dynamic_pcell$5_0.H_DRN.n12 2.16655
R11134 ota_cmfb_top_0.dynamic_pcell$5_0.H_DRN.n15 ota_cmfb_top_0.dynamic_pcell$5_0.H_DRN.n0 4.44881
R11135 ota_cmfb_top_0.dynamic_pcell$5_0.H_DRN.t4 ota_cmfb_top_0.dynamic_pcell$5_0.H_DRN.n12 3.35652
R11136 ota_cmfb_top_0.dynamic_pcell$5_0.H_DRN.n2 ota_cmfb_top_0.dynamic_pcell$5_0.H_DRN 4.69782
R11137 ota_cmfb_top_0.dynamic_pcell$5_0.H_DRN.n13 ota_cmfb_top_0.dynamic_pcell$5_0.H_DRN.n14 2.24024
R11138 ota_cmfb_top_0.dynamic_pcell$5_0.H_DRN.n11 ota_cmfb_top_0.dynamic_pcell$5_0.H_DRN 4.69782
R11139 ota_cmfb_top_0.dynamic_pcell$5_0.H_DRN ota_cmfb_top_0.dynamic_pcell$5_0.H_DRN.n20 7.55637
R11140 ota_cmfb_top_0.dynamic_pcell$5_0.H_DRN.n8 ota_cmfb_top_0.dynamic_pcell$5_0.H_DRN.n7 2.78466
R11141 ota_cmfb_top_0.dynamic_pcell$5_0.H_DRN.n6 ota_cmfb_top_0.dynamic_pcell$5_0.H_DRN.n5 2.78466
R11142 ota_cmfb_top_0.dynamic_pcell$5_0.H_DRN.n4 ota_cmfb_top_0.dynamic_pcell$5_0.H_DRN.n3 2.78466
R11143 ota_cmfb_top_0.dynamic_pcell$5_0.H_DRN.n23 ota_cmfb_top_0.dynamic_pcell$5_0.H_DRN.n22 5.5445
R11144 ota_cmfb_top_0.dynamic_pcell$5_0.H_DRN ota_cmfb_top_0.dynamic_pcell$5_0.H_DRN.n10 4.98604
R11145 ota_cmfb_top_0.dynamic_pcell$5_0.H_DRN ota_cmfb_top_0.dynamic_pcell$5_0.H_DRN.n10 4.54808
R11146 ota_cmfb_top_0.dynamic_pcell$5_0.H_DRN.n7 ota_cmfb_top_0.dynamic_pcell$5_0.H_DRN 5.01307
R11147 ota_cmfb_top_0.dynamic_pcell$5_0.H_DRN.n20 ota_cmfb_top_0.dynamic_pcell$5_0.H_DRN.n13 4.50916
R11148 ota_cmfb_top_0.dynamic_pcell$5_0.H_DRN.n25 ota_cmfb_top_0.dynamic_pcell$5_0.H_DRN.n24 4.0529
R11149 ota_cmfb_top_0.dynamic_pcell$5_0.H_DRN ota_cmfb_top_0.dynamic_pcell$5_0.H_DRN.n16 2.94921
R11150 ota_cmfb_top_0.dynamic_pcell$5_0.H_DRN.n3 ota_cmfb_top_0.dynamic_pcell$5_0.H_DRN 1.72927
R11151 ota_cmfb_top_0.dynamic_pcell$5_0.H_DRN.n18 ota_cmfb_top_0.dynamic_pcell$5_0.H_DRN 0.776645
R11152 ota_cmfb_top_0.dynamic_pcell$5_0.H_DRN.n17 ota_cmfb_top_0.dynamic_pcell$5_0.H_DRN.n16 0.304065
R11153 ota_cmfb_top_0.dynamic_pcell$5_0.H_DRN.n14 ota_cmfb_top_0.dynamic_pcell$5_0.H_DRN 3.02502
R11154 ota_cmfb_top_0.dynamic_pcell$5_0.H_DRN.n17 ota_cmfb_top_0.dynamic_pcell$5_0.H_DRN.n10 0.27681
R11155 ota_cmfb_top_0.dynamic_pcell$5_0.H_DRN.n25 ota_cmfb_top_0.dynamic_pcell$5_0.H_DRN.n9 1.14698
R11156 ota_cmfb_top_0.dynamic_pcell$5_0.H_DRN.n9 ota_cmfb_top_0.dynamic_pcell$5_0.H_DRN.n3 2.30343
R11157 ota_cmfb_top_0.dynamic_pcell$5_0.H_DRN ota_cmfb_top_0.dynamic_pcell$5_0.H_DRN.n5 0.564934
R11158 ota_cmfb_top_0.dynamic_pcell$5_0.H_DRN.n5 ota_cmfb_top_0.dynamic_pcell$5_0.H_DRN.n7 2.2937
R11159 ota_cmfb_top_0.dynamic_pcell$5_0.H_DRN.n11 ota_cmfb_top_0.dynamic_pcell$5_0.H_DRN.n22 2.02244
R11160 ota_cmfb_top_0.dynamic_pcell$5_0.H_DRN.n11 ota_cmfb_top_0.dynamic_pcell$5_0.H_DRN 2.29335
R11161 ota_cmfb_top_0.dynamic_pcell$5_0.H_DRN.n2 ota_cmfb_top_0.dynamic_pcell$5_0.H_DRN.n1 2.10855
R11162 ota_cmfb_top_0.dynamic_pcell$5_0.H_DRN.n1 ota_cmfb_top_0.dynamic_pcell$5_0.H_DRN.n0 0.623327
R11163 ota_cmfb_top_0.dynamic_pcell$5_0.H_DRN.n21 ota_cmfb_top_0.dynamic_pcell$5_0.H_DRN.n20 0.18041
R11164 ota_cmfb_top_0.dynamic_pcell$5_0.H_DRN ota_cmfb_top_0.dynamic_pcell$5_0.H_DRN.n4 3.17858
R11165 ota_cmfb_top_0.dynamic_pcell$5_0.H_DRN.n6 ota_cmfb_top_0.dynamic_pcell$5_0.H_DRN 3.17858
R11166 ota_cmfb_top_0.dynamic_pcell$5_0.H_DRN.n8 ota_cmfb_top_0.dynamic_pcell$5_0.H_DRN 3.17858
R11167 ota_cmfb_top_0.dynamic_pcell$5_0.H_DRN ota_cmfb_top_0.dynamic_pcell$5_0.H_DRN.n16 3.16532
R11168 ota_cmfb_top_0.dynamic_pcell$5_0.H_DRN.n15 ota_cmfb_top_0.dynamic_pcell$5_0.H_DRN.n12 0.0833737
R11169 ota_cmfb_top_0.dynamic_pcell$5_0.H_DRN.n14 ota_cmfb_top_0.dynamic_pcell$5_0.H_DRN.n21 0.378937
R11170 ota_cmfb_top_0.dynamic_pcell$5_0.H_DRN.n22 ota_cmfb_top_0.dynamic_pcell$5_0.H_DRN.n13 3.04974
R11171 ota_cmfb_top_0.dynamic_pcell$5_0.H_DRN ota_cmfb_top_0.dynamic_pcell$5_0.H_DRN.n2 2.29335
C569 ibias0 vss_1v2 19.872f
C570 s5_an[0] vss_1v2 0.1594p
C571 analog_bus0 vss_1v2 15.5444f
C572 analog_bus1 vss_1v2 15.0653f
C573 s5_an[2] vss_1v2 40.84371f
C574 s5_an[1] vss_1v2 28.55377f
C575 enable vss_1v2 36.25587f
C576 vdd_1v2 vss_1v2 0.33786p
C577 m5_101852_18441# vss_1v2 4.43719f ; **FLOATING
C578 m5_97502_13341r# vss_1v2 6.42589f
C579 m5_93152_13941r# vss_1v2 6.40444f
C580 m5_88802_13191# vss_1v2 6.20625f
C581 m5_84452_13191# vss_1v2 5.66564f
C582 m5_81602_13191# vss_1v2 3.56904f
C583 m5_77252_13191r# vss_1v2 5.54773f
C584 m5_72902_13191# vss_1v2 6.34528f
C585 m5_68552_16641r# vss_1v2 4.99035f
C586 slot5_wrapper_0.vss_3v3 vss_1v2 2.53718f
C587 m5_35980_52238# vss_1v2 4.43719f ; **FLOATING
C588 m5_31630_47138r# vss_1v2 6.42589f
C589 m5_27280_47738r# vss_1v2 6.40444f
C590 m5_22930_46988# vss_1v2 6.20625f
C591 m5_18580_46988# vss_1v2 5.66564f
C592 m5_15730_46988# vss_1v2 3.56904f
C593 m5_11380_46988r# vss_1v2 5.54773f
C594 m5_7030_46988# vss_1v2 6.34528f
C595 m5_2680_50438r# vss_1v2 4.99035f
C596 slot5_wrapper_0.vdd_3v3 vss_1v2 8.76404f
C597 slot5_wrapper_0.s5_an_0_esd vss_1v2 0.15069f ; **FLOATING
C598 slot5_wrapper_0.dig_out[0] vss_1v2 0.13023f
C599 slot5_wrapper_0.dig_out[1] vss_1v2 0.04024f
C600 slot5_wrapper_0.dig_out[2] vss_1v2 0.04024f
C601 slot5_wrapper_0.dig_out[3] vss_1v2 0.04024f
C602 slot5_wrapper_0.dig_out[4] vss_1v2 0.04024f
C603 slot5_wrapper_0.dig_out[5] vss_1v2 0.04024f
C604 slot5_wrapper_0.dig_out[6] vss_1v2 0.04024f
C605 slot5_wrapper_0.dig_out[7] vss_1v2 0.04024f
C606 slot5_wrapper_0.dig_out[8] vss_1v2 0.04024f
C607 slot5_wrapper_0.dig_out[9] vss_1v2 0.04024f
C608 slot5_wrapper_0.dig_out[10] vss_1v2 0.04024f
C609 slot5_wrapper_0.dig_out[11] vss_1v2 0.05738f
C610 slot5_wrapper_0.dig_in[0] vss_1v2 0.05738f
C611 slot5_wrapper_0.dig_in[1] vss_1v2 0.04024f
C612 slot5_wrapper_0.dig_in[2] vss_1v2 0.04024f
C613 slot5_wrapper_0.dig_in[3] vss_1v2 0.04024f
C614 slot5_wrapper_0.dig_in[4] vss_1v2 0.04024f
C615 slot5_wrapper_0.dig_in[5] vss_1v2 0.04024f
C616 slot5_wrapper_0.dig_in[6] vss_1v2 0.04024f
C617 slot5_wrapper_0.dig_in[7] vss_1v2 0.04024f
C618 slot5_wrapper_0.dig_in[8] vss_1v2 0.04024f
C619 slot5_wrapper_0.dig_in[9] vss_1v2 0.04024f
C620 slot5_wrapper_0.dig_in[10] vss_1v2 0.04024f
C621 slot5_wrapper_0.dig_in[11] vss_1v2 0.04024f
C622 slot5_wrapper_0.dig_in[12] vss_1v2 0.04024f
C623 slot5_wrapper_0.dig_in[13] vss_1v2 0.04024f
C624 slot5_wrapper_0.dig_in[14] vss_1v2 0.04024f
C625 slot5_wrapper_0.dig_in[15] vss_1v2 0.04024f
C626 slot5_wrapper_0.dig_in[16] vss_1v2 0.04024f
C627 slot5_wrapper_0.dig_in[17] vss_1v2 0.04024f
C628 slot5_wrapper_0.dig_in[18] vss_1v2 0.04024f
C629 slot5_wrapper_0.dig_in[19] vss_1v2 0.04024f
C630 slot5_wrapper_0.dig_in[20] vss_1v2 0.04024f
C631 slot5_wrapper_0.dig_in[21] vss_1v2 0.04024f
C632 slot5_wrapper_0.dig_in[22] vss_1v2 0.04024f
C633 slot5_wrapper_0.dig_in[23] vss_1v2 0.04024f
C634 slot5_wrapper_0.reset vss_1v2 0.04044f
C635 slot5_wrapper_0.clk vss_1v2 0.09077f
C636 m3_0_18723# vss_1v2 0.09889f
C637 slot5_wrapper_0.vbias vss_1v2 0.29582f
C638 m3_0_19311# vss_1v2 0.03587f
C639 m3_0_19899# vss_1v2 0.03077f
C640 slot5_wrapper_0.ibias1 vss_1v2 0.18745f
C641 m3_0_20487# vss_1v2 0.02939f
C642 slot5_wrapper_0.analog_bus3 vss_1v2 0.18025f
C643 m3_0_21075# vss_1v2 0.02853f
C644 slot5_wrapper_0.analog_bus2 vss_1v2 0.17696f
C645 m3_0_21663# vss_1v2 0.02853f
C646 m3_0_22251# vss_1v2 0.02844f
C647 m3_0_22839# vss_1v2 0.08667f
C648 slot5_wrapper_0.s5_an_1_esd vss_1v2 0.15069f ; **FLOATING
C649 ota_cmfb_top_0.ota_cmfb_core_push_pull_output_stage_0/dynamic_pcell$4_0.SRC_NET_ML vss_1v2 4.12342f ; **FLOATING
C650 ota_cmfb_top_0.ota_cmfb_core_push_pull_output_stage_0/dynamic_pcell$4_0.DRN_NET_OP_GATE_MP vss_1v2 16.4037f ; **FLOATING
C651 ota_cmfb_top_0.ota_cmfb_core_push_pull_output_stage_1/dynamic_pcell$4_0.SRC_NET_ML vss_1v2 4.08965f ; **FLOATING
C652 ota_cmfb_top_0.ota_cmfb_core_push_pull_output_stage_1/dynamic_pcell$4_0.DRN_NET_OP_GATE_MP vss_1v2 16.3868f ; **FLOATING
C653 ota_cmfb_top_0.ota_cmfb_core_push_pull_output_stage_0/dynamic_pcell$4_0.Gate vss_1v2 26.9332f ; **FLOATING
C654 ota_cmfb_top_0.ota_cmfb_core_push_pull_output_stage_1/dynamic_pcell$4_0.Gate vss_1v2 26.8935f ; **FLOATING
C655 ota_cmfb_top_0.ota_cmfb_core_push_pull_output_stage_0/EN_INV_0/sg13cmos5l_inv_4_0.Y vss_1v2 0.67513f ; **FLOATING
C656 ota_cmfb_top_0.ota_cmfb_core_push_pull_output_stage_1/EN_INV_0/sg13cmos5l_inv_4_0.Y vss_1v2 0.65842f ; **FLOATING
C657 ota_cmfb_top_0.ota_cmfb_core_push_pull_output_stage_0/dynamic_pcell$4_0.DRN_NET_MENX vss_1v2 10.1624f ; **FLOATING
C658 ota_cmfb_top_0.ota_cmfb_core_push_pull_output_stage_0/dynamic_pcell$4_0.DRN_NET_HI vss_1v2 0.04792f ; **FLOATING
C659 ota_cmfb_top_0.ota_cmfb_core_push_pull_output_stage_0/dynamic_pcell$4_0.DRN_NET_J_GATE_EJ vss_1v2 3.69526f ; **FLOATING
C660 ota_cmfb_top_0.ota_cmfb_core_push_pull_output_stage_0/dynamic_pcell$4_0.DRN_NET_CD vss_1v2 0.03682f ; **FLOATING
C661 ota_cmfb_top_0.ota_cmfb_core_push_pull_output_stage_0/dynamic_pcell$4_0.B_DRN vss_1v2 11.6631f ; **FLOATING
C662 ota_cmfb_top_0.ota_cmfb_core_push_pull_output_stage_0/dynamic_pcell$4_0.SRC_NET_IJ_GATE_DI vss_1v2 0.19735f ; **FLOATING
C663 a_50924_27132# vss_1v2 0.35249f ; **FLOATING
C664 a_50660_27418# vss_1v2 0.28221f ; **FLOATING
C665 a_50396_27132# vss_1v2 0.33612f ; **FLOATING
C666 a_50132_27418# vss_1v2 0.28198f ; **FLOATING
C667 a_49868_27132# vss_1v2 0.33602f ; **FLOATING
C668 a_49604_27418# vss_1v2 0.28211f ; **FLOATING
C669 a_49340_27132# vss_1v2 0.33611f ; **FLOATING
C670 a_49076_27418# vss_1v2 0.28255f ; **FLOATING
C671 a_48812_27132# vss_1v2 0.3601f ; **FLOATING
C672 a_50924_27979# vss_1v2 0.28587f ; **FLOATING
C673 a_50660_27693# vss_1v2 0.27427f ; **FLOATING
C674 a_50396_27979# vss_1v2 0.27566f ; **FLOATING
C675 a_50132_27693# vss_1v2 0.27424f ; **FLOATING
C676 a_49868_27979# vss_1v2 0.27488f ; **FLOATING
C677 a_49604_27693# vss_1v2 0.27448f ; **FLOATING
C678 a_49340_27979# vss_1v2 0.2751f ; **FLOATING
C679 a_49076_27693# vss_1v2 0.27513f ; **FLOATING
C680 ota_cmfb_top_0.dynamic_pcell$5_0.DRN_NET_E_GATE_CDEFGH vss_1v2 0.10783p ; **FLOATING
C681 ota_cmfb_top_0.EN_INV_1/sg13cmos5l_inv_4_0.Y vss_1v2 0.65799f ; **FLOATING
C682 ota_cmfb_top_0.EN_INV_0/sg13cmos5l_inv_4_0.Y vss_1v2 0.64157f ; **FLOATING
C683 a_48812_27979# vss_1v2 0.29386f ; **FLOATING
C684 ota_cmfb_top_0.ota_cmfb_core_push_pull_output_stage_1/dynamic_pcell$4_0.DRN_NET_MENX vss_1v2 10.0816f ; **FLOATING
C685 ota_cmfb_top_0.ota_cmfb_core_push_pull_output_stage_1/dynamic_pcell$4_0.DRN_NET_HI vss_1v2 0.01194f ; **FLOATING
C686 ota_cmfb_top_0.ota_cmfb_core_push_pull_output_stage_1/dynamic_pcell$4_0.DRN_NET_J_GATE_EJ vss_1v2 2.06026f ; **FLOATING
C687 ota_cmfb_top_0.ota_cmfb_core_push_pull_output_stage_1/dynamic_pcell$4_0.DRN_NET_CD vss_1v2 0.01813f ; **FLOATING
C688 ota_cmfb_top_0.ota_cmfb_core_push_pull_output_stage_1/dynamic_pcell$4_0.B_DRN vss_1v2 11.3869f ; **FLOATING
C689 ota_cmfb_top_0.ota_cmfb_core_push_pull_output_stage_1/dynamic_pcell$4_0.SRC_NET_IJ_GATE_DI vss_1v2 0.05876f ; **FLOATING
C690 ota_cmfb_top_0.dynamic_pcell$5_0.F_DRN vss_1v2 83.47597f ; **FLOATING
C691 ota_cmfb_top_0.dynamic_pcell$5_0.G_DRN vss_1v2 86.01506f ; **FLOATING
C692 ota_cmfb_top_0.dynamic_pcell$5_0.Gate vss_1v2 32.1491f ; **FLOATING
C693 ota_cmfb_top_0.dynamic_pcell$5_0.SRC_NET_AB vss_1v2 0.45892f ; **FLOATING
C694 ota_cmfb_top_0.dynamic_pcell$5_0.L_GATE vss_1v2 0.91839f ; **FLOATING
C695 ota_cmfb_top_0.dynamic_pcell$5_0.DRN_NET_BD vss_1v2 7.4335f ; **FLOATING
C696 a_58930_33631# vss_1v2 0.30752f ; **FLOATING
C697 a_58666_33917# vss_1v2 0.27002f ; **FLOATING
C698 a_58402_33631# vss_1v2 0.32348f ; **FLOATING
C699 a_58930_34440# vss_1v2 0.33585f ; **FLOATING
C700 a_58666_34154# vss_1v2 0.27644f ; **FLOATING
C701 a_58402_33917# vss_1v2 0.32239f ; **FLOATING
C702 a_58402_34440# vss_1v2 0.34946f ; **FLOATING
C703 ota_cmfb_top_0.dynamic_pcell$5_0.DRN_NET_CA vss_1v2 8.48447f ; **FLOATING
C704 a_52197_33631# vss_1v2 0.30752f ; **FLOATING
C705 a_51933_33917# vss_1v2 0.27002f ; **FLOATING
C706 a_51669_33631# vss_1v2 0.31533f ; **FLOATING
C707 ota_cmfb_top_0.dynamic_pcell$5_0.DRN_NET_JL vss_1v2 66.42796f ; **FLOATING
C708 a_52197_34440# vss_1v2 0.33585f ; **FLOATING
C709 a_51933_34154# vss_1v2 0.27644f ; **FLOATING
C710 a_51669_33917# vss_1v2 0.30295f ; **FLOATING
C711 a_51669_34440# vss_1v2 0.34279f ; **FLOATING
C712 ota_cmfb_top_0.dynamic_pcell$5_0.SRC_NET_KL vss_1v2 13.62654f ; **FLOATING
C713 ota_cmfb_top_0.dynamic_pcell$5_0.H_DRN vss_1v2 32.73551f ; **FLOATING
C714 w_59515_33612# vss_1v2 0.94041f ; **FLOATING
C715 w_52782_33612# vss_1v2 0.93848f ; **FLOATING
C716 ota_cmfb_top_0.dynamic_pcell$5_0.H_DRN.n0 vss_1v2 0.1349f ; **FLOATING
C717 ota_cmfb_top_0.dynamic_pcell$5_0.H_DRN.n1 vss_1v2 0.17671f ; **FLOATING
C718 ota_cmfb_top_0.dynamic_pcell$5_0.H_DRN.n2 vss_1v2 1.20706f ; **FLOATING
C719 ota_cmfb_top_0.dynamic_pcell$5_0.H_DRN.n3 vss_1v2 0.70951f ; **FLOATING
C720 ota_cmfb_top_0.dynamic_pcell$5_0.H_DRN.n4 vss_1v2 0.6013f ; **FLOATING
C721 ota_cmfb_top_0.dynamic_pcell$5_0.H_DRN.n5 vss_1v2 0.63086f ; **FLOATING
C722 ota_cmfb_top_0.dynamic_pcell$5_0.H_DRN.n6 vss_1v2 0.6013f ; **FLOATING
C723 ota_cmfb_top_0.dynamic_pcell$5_0.H_DRN.n7 vss_1v2 0.82129f ; **FLOATING
C724 ota_cmfb_top_0.dynamic_pcell$5_0.H_DRN.n8 vss_1v2 0.6013f ; **FLOATING
C725 ota_cmfb_top_0.dynamic_pcell$5_0.H_DRN.n9 vss_1v2 0.92945f ; **FLOATING
C726 ota_cmfb_top_0.dynamic_pcell$5_0.H_DRN.n10 vss_1v2 0.04412f ; **FLOATING
C727 ota_cmfb_top_0.dynamic_pcell$5_0.H_DRN.n11 vss_1v2 1.23862f ; **FLOATING
C728 ota_cmfb_top_0.dynamic_pcell$5_0.H_DRN.n12 vss_1v2 0.9108f ; **FLOATING
C729 ota_cmfb_top_0.dynamic_pcell$5_0.H_DRN.n13 vss_1v2 1.28534f ; **FLOATING
C730 ota_cmfb_top_0.dynamic_pcell$5_0.H_DRN.n14 vss_1v2 0.07224f ; **FLOATING
C731 ota_cmfb_top_0.dynamic_pcell$5_0.H_DRN.t5 vss_1v2 2.63466f ; **FLOATING
C732 ota_cmfb_top_0.dynamic_pcell$5_0.H_DRN.n15 vss_1v2 0.93446f ; **FLOATING
C733 ota_cmfb_top_0.dynamic_pcell$5_0.H_DRN.t4 vss_1v2 2.3493f ; **FLOATING
C734 ota_cmfb_top_0.dynamic_pcell$5_0.H_DRN.n16 vss_1v2 0.06565f ; **FLOATING
C735 ota_cmfb_top_0.dynamic_pcell$5_0.H_DRN.n17 vss_1v2 0.03937f ; **FLOATING
C736 ota_cmfb_top_0.dynamic_pcell$5_0.H_DRN.t3 vss_1v2 0.04254f ; **FLOATING
C737 ota_cmfb_top_0.dynamic_pcell$5_0.H_DRN.t2 vss_1v2 0.04305f ; **FLOATING
C738 ota_cmfb_top_0.dynamic_pcell$5_0.H_DRN.n18 vss_1v2 1.76291f ; **FLOATING
C739 ota_cmfb_top_0.dynamic_pcell$5_0.H_DRN.n19 vss_1v2 1.64363f ; **FLOATING
C740 ota_cmfb_top_0.dynamic_pcell$5_0.H_DRN.t6 vss_1v2 0.21012f ; **FLOATING
C741 ota_cmfb_top_0.dynamic_pcell$5_0.H_DRN.t0 vss_1v2 0.15219f ; **FLOATING
C742 ota_cmfb_top_0.dynamic_pcell$5_0.H_DRN.n20 vss_1v2 0.0354f ; **FLOATING
C743 ota_cmfb_top_0.dynamic_pcell$5_0.H_DRN.n21 vss_1v2 0.03817f ; **FLOATING
C744 ota_cmfb_top_0.dynamic_pcell$5_0.H_DRN.n22 vss_1v2 0.44412f ; **FLOATING
C745 ota_cmfb_top_0.dynamic_pcell$5_0.H_DRN.n23 vss_1v2 0.63118f ; **FLOATING
C746 ota_cmfb_top_0.dynamic_pcell$5_0.H_DRN.n24 vss_1v2 0.51904f ; **FLOATING
C747 ota_cmfb_top_0.dynamic_pcell$5_0.H_DRN.n25 vss_1v2 0.31294f ; **FLOATING
C748 ota_cmfb_top_0.dynamic_pcell$5_0.H_DRN.t1 vss_1v2 0.15109f ; **FLOATING
C749 ota_cmfb_top_0.dynamic_pcell$5_0.SRC_NET_KL.n0 vss_1v2 0.58656f ; **FLOATING
C750 ota_cmfb_top_0.dynamic_pcell$5_0.SRC_NET_KL.n1 vss_1v2 0.75854f ; **FLOATING
C751 ota_cmfb_top_0.dynamic_pcell$5_0.SRC_NET_KL.t5 vss_1v2 0.36591f ; **FLOATING
C752 ota_cmfb_top_0.dynamic_pcell$5_0.SRC_NET_KL.t4 vss_1v2 0.36591f ; **FLOATING
C753 ota_cmfb_top_0.dynamic_pcell$5_0.SRC_NET_KL.n2 vss_1v2 0.4702f ; **FLOATING
C754 ota_cmfb_top_0.dynamic_pcell$5_0.SRC_NET_KL.n3 vss_1v2 1.08334f ; **FLOATING
C755 ota_cmfb_top_0.dynamic_pcell$5_0.SRC_NET_KL.t7 vss_1v2 0.36859f ; **FLOATING
C756 ota_cmfb_top_0.dynamic_pcell$5_0.SRC_NET_KL.t6 vss_1v2 0.36859f ; **FLOATING
C757 ota_cmfb_top_0.dynamic_pcell$5_0.SRC_NET_KL.n4 vss_1v2 0.63833f ; **FLOATING
C758 ota_cmfb_top_0.dynamic_pcell$5_0.SRC_NET_KL.n5 vss_1v2 1.21005f ; **FLOATING
C759 ota_cmfb_top_0.dynamic_pcell$5_0.SRC_NET_KL.n6 vss_1v2 0.78372f ; **FLOATING
C760 ota_cmfb_top_0.dynamic_pcell$5_0.SRC_NET_KL.t0 vss_1v2 0.80059f ; **FLOATING
C761 ota_cmfb_top_0.dynamic_pcell$5_0.SRC_NET_KL.t2 vss_1v2 0.66886f ; **FLOATING
C762 ota_cmfb_top_0.dynamic_pcell$5_0.SRC_NET_KL.n7 vss_1v2 0.94179f ; **FLOATING
C763 ota_cmfb_top_0.dynamic_pcell$5_0.SRC_NET_KL.t1 vss_1v2 0.73067f ; **FLOATING
C764 ota_cmfb_top_0.dynamic_pcell$5_0.SRC_NET_KL.t3 vss_1v2 0.86243f ; **FLOATING
C765 ota_cmfb_top_0.dynamic_pcell$5_0.DRN_NET_JL.n0 vss_1v2 0.17838f ; **FLOATING
C766 ota_cmfb_top_0.dynamic_pcell$5_0.DRN_NET_JL.n1 vss_1v2 0.17838f ; **FLOATING
C767 ota_cmfb_top_0.dynamic_pcell$5_0.DRN_NET_JL.n2 vss_1v2 0.17838f ; **FLOATING
C768 ota_cmfb_top_0.dynamic_pcell$5_0.DRN_NET_JL.n3 vss_1v2 0.09479f ; **FLOATING
C769 ota_cmfb_top_0.dynamic_pcell$5_0.DRN_NET_JL.n4 vss_1v2 0.11048f ; **FLOATING
C770 ota_cmfb_top_0.dynamic_pcell$5_0.DRN_NET_JL.n5 vss_1v2 0.09479f ; **FLOATING
C771 ota_cmfb_top_0.dynamic_pcell$5_0.DRN_NET_JL.n6 vss_1v2 0.11048f ; **FLOATING
C772 ota_cmfb_top_0.dynamic_pcell$5_0.DRN_NET_JL.n7 vss_1v2 0.09479f ; **FLOATING
C773 ota_cmfb_top_0.dynamic_pcell$5_0.DRN_NET_JL.n8 vss_1v2 0.11048f ; **FLOATING
C774 ota_cmfb_top_0.dynamic_pcell$5_0.DRN_NET_JL.n9 vss_1v2 0.07574f ; **FLOATING
C775 ota_cmfb_top_0.dynamic_pcell$5_0.DRN_NET_JL.n10 vss_1v2 0.1526f ; **FLOATING
C776 ota_cmfb_top_0.dynamic_pcell$5_0.DRN_NET_JL.n11 vss_1v2 0.0767f ; **FLOATING
C777 ota_cmfb_top_0.dynamic_pcell$5_0.DRN_NET_JL.n12 vss_1v2 0.10588f ; **FLOATING
C778 ota_cmfb_top_0.dynamic_pcell$5_0.DRN_NET_JL.n13 vss_1v2 0.0767f ; **FLOATING
C779 ota_cmfb_top_0.dynamic_pcell$5_0.DRN_NET_JL.n14 vss_1v2 0.10588f ; **FLOATING
C780 ota_cmfb_top_0.dynamic_pcell$5_0.DRN_NET_JL.n15 vss_1v2 0.0767f ; **FLOATING
C781 ota_cmfb_top_0.dynamic_pcell$5_0.DRN_NET_JL.n16 vss_1v2 0.10588f ; **FLOATING
C782 ota_cmfb_top_0.dynamic_pcell$5_0.DRN_NET_JL.n17 vss_1v2 0.17402f ; **FLOATING
C783 ota_cmfb_top_0.dynamic_pcell$5_0.DRN_NET_JL.n18 vss_1v2 0.17402f ; **FLOATING
C784 ota_cmfb_top_0.dynamic_pcell$5_0.DRN_NET_JL.n19 vss_1v2 0.17402f ; **FLOATING
C785 ota_cmfb_top_0.dynamic_pcell$5_0.DRN_NET_JL.n20 vss_1v2 0.24229f ; **FLOATING
C786 ota_cmfb_top_0.dynamic_pcell$5_0.DRN_NET_JL.n21 vss_1v2 0.24229f ; **FLOATING
C787 ota_cmfb_top_0.dynamic_pcell$5_0.DRN_NET_JL.n22 vss_1v2 0.26604f ; **FLOATING
C788 ota_cmfb_top_0.dynamic_pcell$5_0.DRN_NET_JL.n23 vss_1v2 0.0767f ; **FLOATING
C789 ota_cmfb_top_0.dynamic_pcell$5_0.DRN_NET_JL.n24 vss_1v2 0.10588f ; **FLOATING
C790 ota_cmfb_top_0.dynamic_pcell$5_0.DRN_NET_JL.n25 vss_1v2 0.27214f ; **FLOATING
C791 ota_cmfb_top_0.dynamic_pcell$5_0.DRN_NET_JL.n26 vss_1v2 0.16041f ; **FLOATING
C792 ota_cmfb_top_0.dynamic_pcell$5_0.DRN_NET_JL.t2 vss_1v2 0.2157f ; **FLOATING
C793 ota_cmfb_top_0.dynamic_pcell$5_0.DRN_NET_JL.n27 vss_1v2 0.31163f ; **FLOATING
C794 ota_cmfb_top_0.dynamic_pcell$5_0.DRN_NET_JL.n28 vss_1v2 0.19624f ; **FLOATING
C795 ota_cmfb_top_0.dynamic_pcell$5_0.DRN_NET_JL.n29 vss_1v2 0.20394f ; **FLOATING
C796 ota_cmfb_top_0.dynamic_pcell$5_0.DRN_NET_JL.n30 vss_1v2 1.02738f ; **FLOATING
C797 ota_cmfb_top_0.dynamic_pcell$5_0.DRN_NET_JL.t4 vss_1v2 0.03119f ; **FLOATING
C798 ota_cmfb_top_0.dynamic_pcell$5_0.DRN_NET_JL.t3 vss_1v2 0.03119f ; **FLOATING
C799 ota_cmfb_top_0.dynamic_pcell$5_0.DRN_NET_JL.n31 vss_1v2 1.06532f ; **FLOATING
C800 ota_cmfb_top_0.dynamic_pcell$5_0.DRN_NET_JL.t1 vss_1v2 0.20524f ; **FLOATING
C801 ota_cmfb_top_0.dynamic_pcell$5_0.DRN_NET_JL.n32 vss_1v2 0.89242f ; **FLOATING
C802 ota_cmfb_top_0.dynamic_pcell$5_0.DRN_NET_JL.n33 vss_1v2 0.2156f ; **FLOATING
C803 ota_cmfb_top_0.dynamic_pcell$5_0.DRN_NET_JL.t0 vss_1v2 0.24022f ; **FLOATING
C804 ota_cmfb_top_0.dynamic_pcell$5_0.G_DRN.n0 vss_1v2 0.09746f ; **FLOATING
C805 ota_cmfb_top_0.dynamic_pcell$5_0.G_DRN.n1 vss_1v2 0.05165f ; **FLOATING
C806 ota_cmfb_top_0.dynamic_pcell$5_0.G_DRN.n2 vss_1v2 0.05879f ; **FLOATING
C807 ota_cmfb_top_0.dynamic_pcell$5_0.G_DRN.n3 vss_1v2 0.05165f ; **FLOATING
C808 ota_cmfb_top_0.dynamic_pcell$5_0.G_DRN.n4 vss_1v2 0.05879f ; **FLOATING
C809 ota_cmfb_top_0.dynamic_pcell$5_0.G_DRN.n5 vss_1v2 0.05378f ; **FLOATING
C810 ota_cmfb_top_0.dynamic_pcell$5_0.G_DRN.n6 vss_1v2 0.06135f ; **FLOATING
C811 ota_cmfb_top_0.dynamic_pcell$5_0.G_DRN.n7 vss_1v2 0.02334f ; **FLOATING
C812 ota_cmfb_top_0.dynamic_pcell$5_0.G_DRN.n8 vss_1v2 0.04298f ; **FLOATING
C813 ota_cmfb_top_0.dynamic_pcell$5_0.G_DRN.n9 vss_1v2 0.08728f ; **FLOATING
C814 ota_cmfb_top_0.dynamic_pcell$5_0.G_DRN.n10 vss_1v2 0.07152f ; **FLOATING
C815 ota_cmfb_top_0.dynamic_pcell$5_0.G_DRN.n11 vss_1v2 0.1279f ; **FLOATING
C816 ota_cmfb_top_0.dynamic_pcell$5_0.G_DRN.n12 vss_1v2 0.07152f ; **FLOATING
C817 ota_cmfb_top_0.dynamic_pcell$5_0.G_DRN.n13 vss_1v2 0.1279f ; **FLOATING
C818 ota_cmfb_top_0.dynamic_pcell$5_0.G_DRN.n14 vss_1v2 0.34493f ; **FLOATING
C819 ota_cmfb_top_0.dynamic_pcell$5_0.G_DRN.n15 vss_1v2 0.45227f ; **FLOATING
C820 ota_cmfb_top_0.dynamic_pcell$5_0.G_DRN.n16 vss_1v2 0.46927f ; **FLOATING
C821 ota_cmfb_top_0.dynamic_pcell$5_0.G_DRN.n17 vss_1v2 0.45227f ; **FLOATING
C822 ota_cmfb_top_0.dynamic_pcell$5_0.G_DRN.n18 vss_1v2 0.46105f ; **FLOATING
C823 ota_cmfb_top_0.dynamic_pcell$5_0.G_DRN.n19 vss_1v2 0.45227f ; **FLOATING
C824 ota_cmfb_top_0.dynamic_pcell$5_0.G_DRN.n20 vss_1v2 0.45227f ; **FLOATING
C825 ota_cmfb_top_0.dynamic_pcell$5_0.G_DRN.n21 vss_1v2 0.5596f ; **FLOATING
C826 ota_cmfb_top_0.dynamic_pcell$5_0.G_DRN.n22 vss_1v2 0.5684f ; **FLOATING
C827 ota_cmfb_top_0.dynamic_pcell$5_0.G_DRN.n23 vss_1v2 0.12821f ; **FLOATING
C828 ota_cmfb_top_0.dynamic_pcell$5_0.G_DRN.n24 vss_1v2 0.03108f ; **FLOATING
C829 ota_cmfb_top_0.dynamic_pcell$5_0.G_DRN.n25 vss_1v2 0.02334f ; **FLOATING
C830 ota_cmfb_top_0.dynamic_pcell$5_0.G_DRN.t13 vss_1v2 0.07204f ; **FLOATING
C831 ota_cmfb_top_0.dynamic_pcell$5_0.G_DRN.n26 vss_1v2 0.41198f ; **FLOATING
C832 ota_cmfb_top_0.dynamic_pcell$5_0.G_DRN.n27 vss_1v2 0.05713f ; **FLOATING
C833 ota_cmfb_top_0.dynamic_pcell$5_0.G_DRN.n28 vss_1v2 0.02334f ; **FLOATING
C834 ota_cmfb_top_0.dynamic_pcell$5_0.G_DRN.n29 vss_1v2 0.03108f ; **FLOATING
C835 ota_cmfb_top_0.dynamic_pcell$5_0.G_DRN.n30 vss_1v2 0.04449f ; **FLOATING
C836 ota_cmfb_top_0.dynamic_pcell$5_0.G_DRN.n31 vss_1v2 0.3724f ; **FLOATING
C837 ota_cmfb_top_0.dynamic_pcell$5_0.G_DRN.n32 vss_1v2 0.2474f ; **FLOATING
C838 ota_cmfb_top_0.dynamic_pcell$5_0.G_DRN.n33 vss_1v2 0.55938f ; **FLOATING
C839 ota_cmfb_top_0.dynamic_pcell$5_0.G_DRN.t6 vss_1v2 0.2946f ; **FLOATING
C840 ota_cmfb_top_0.dynamic_pcell$5_0.G_DRN.n34 vss_1v2 0.08447f ; **FLOATING
C841 ota_cmfb_top_0.dynamic_pcell$5_0.G_DRN.n35 vss_1v2 0.03108f ; **FLOATING
C842 ota_cmfb_top_0.dynamic_pcell$5_0.G_DRN.n36 vss_1v2 0.02942f ; **FLOATING
C843 ota_cmfb_top_0.dynamic_pcell$5_0.G_DRN.n37 vss_1v2 0.02334f ; **FLOATING
C844 ota_cmfb_top_0.dynamic_pcell$5_0.G_DRN.t4 vss_1v2 0.2946f ; **FLOATING
C845 ota_cmfb_top_0.dynamic_pcell$5_0.G_DRN.n38 vss_1v2 0.0467f ; **FLOATING
C846 ota_cmfb_top_0.dynamic_pcell$5_0.G_DRN.n39 vss_1v2 0.03108f ; **FLOATING
C847 ota_cmfb_top_0.dynamic_pcell$5_0.G_DRN.n40 vss_1v2 0.03108f ; **FLOATING
C848 ota_cmfb_top_0.dynamic_pcell$5_0.G_DRN.t3 vss_1v2 0.27029f ; **FLOATING
C849 ota_cmfb_top_0.dynamic_pcell$5_0.G_DRN.n41 vss_1v2 0.05726f ; **FLOATING
C850 ota_cmfb_top_0.dynamic_pcell$5_0.G_DRN.n42 vss_1v2 0.02334f ; **FLOATING
C851 ota_cmfb_top_0.dynamic_pcell$5_0.G_DRN.n43 vss_1v2 0.31825f ; **FLOATING
C852 ota_cmfb_top_0.dynamic_pcell$5_0.G_DRN.n44 vss_1v2 0.27115f ; **FLOATING
C853 ota_cmfb_top_0.dynamic_pcell$5_0.G_DRN.t2 vss_1v2 0.04165f ; **FLOATING
C854 ota_cmfb_top_0.dynamic_pcell$5_0.G_DRN.t1 vss_1v2 0.04053f ; **FLOATING
C855 ota_cmfb_top_0.dynamic_pcell$5_0.G_DRN.n45 vss_1v2 0.03108f ; **FLOATING
C856 ota_cmfb_top_0.dynamic_pcell$5_0.G_DRN.n46 vss_1v2 0.02334f ; **FLOATING
C857 ota_cmfb_top_0.dynamic_pcell$5_0.G_DRN.n47 vss_1v2 0.11951f ; **FLOATING
C858 ota_cmfb_top_0.dynamic_pcell$5_0.G_DRN.n48 vss_1v2 0.02334f ; **FLOATING
C859 ota_cmfb_top_0.dynamic_pcell$5_0.G_DRN.n49 vss_1v2 0.03108f ; **FLOATING
C860 ota_cmfb_top_0.dynamic_pcell$5_0.G_DRN.n50 vss_1v2 0.04449f ; **FLOATING
C861 ota_cmfb_top_0.dynamic_pcell$5_0.G_DRN.n51 vss_1v2 0.34248f ; **FLOATING
C862 ota_cmfb_top_0.dynamic_pcell$5_0.G_DRN.n52 vss_1v2 1.93213f ; **FLOATING
C863 ota_cmfb_top_0.dynamic_pcell$5_0.G_DRN.n53 vss_1v2 0.07622f ; **FLOATING
C864 ota_cmfb_top_0.dynamic_pcell$5_0.G_DRN.n54 vss_1v2 0.3346f ; **FLOATING
C865 ota_cmfb_top_0.dynamic_pcell$5_0.G_DRN.n55 vss_1v2 0.30872f ; **FLOATING
C866 ota_cmfb_top_0.dynamic_pcell$5_0.G_DRN.n56 vss_1v2 0.12822f ; **FLOATING
C867 ota_cmfb_top_0.dynamic_pcell$5_0.G_DRN.t11 vss_1v2 0.30595f ; **FLOATING
C868 ota_cmfb_top_0.dynamic_pcell$5_0.G_DRN.n57 vss_1v2 0.08168f ; **FLOATING
C869 ota_cmfb_top_0.dynamic_pcell$5_0.G_DRN.n58 vss_1v2 0.46467f ; **FLOATING
C870 ota_cmfb_top_0.dynamic_pcell$5_0.G_DRN.t9 vss_1v2 0.30595f ; **FLOATING
C871 ota_cmfb_top_0.dynamic_pcell$5_0.G_DRN.n59 vss_1v2 0.10073f ; **FLOATING
C872 ota_cmfb_top_0.dynamic_pcell$5_0.G_DRN.n60 vss_1v2 0.12826f ; **FLOATING
C873 ota_cmfb_top_0.dynamic_pcell$5_0.G_DRN.n61 vss_1v2 0.18509f ; **FLOATING
C874 ota_cmfb_top_0.dynamic_pcell$5_0.G_DRN.t0 vss_1v2 0.30595f ; **FLOATING
C875 ota_cmfb_top_0.dynamic_pcell$5_0.F_DRN.n0 vss_1v2 0.09334f ; **FLOATING
C876 ota_cmfb_top_0.dynamic_pcell$5_0.F_DRN.n1 vss_1v2 0.04947f ; **FLOATING
C877 ota_cmfb_top_0.dynamic_pcell$5_0.F_DRN.n2 vss_1v2 0.05631f ; **FLOATING
C878 ota_cmfb_top_0.dynamic_pcell$5_0.F_DRN.n3 vss_1v2 0.04947f ; **FLOATING
C879 ota_cmfb_top_0.dynamic_pcell$5_0.F_DRN.n4 vss_1v2 0.05631f ; **FLOATING
C880 ota_cmfb_top_0.dynamic_pcell$5_0.F_DRN.n5 vss_1v2 0.05152f ; **FLOATING
C881 ota_cmfb_top_0.dynamic_pcell$5_0.F_DRN.n6 vss_1v2 0.05876f ; **FLOATING
C882 ota_cmfb_top_0.dynamic_pcell$5_0.F_DRN.n7 vss_1v2 0.02235f ; **FLOATING
C883 ota_cmfb_top_0.dynamic_pcell$5_0.F_DRN.n8 vss_1v2 0.04117f ; **FLOATING
C884 ota_cmfb_top_0.dynamic_pcell$5_0.F_DRN.n9 vss_1v2 0.0836f ; **FLOATING
C885 ota_cmfb_top_0.dynamic_pcell$5_0.F_DRN.n10 vss_1v2 0.06851f ; **FLOATING
C886 ota_cmfb_top_0.dynamic_pcell$5_0.F_DRN.n11 vss_1v2 0.1225f ; **FLOATING
C887 ota_cmfb_top_0.dynamic_pcell$5_0.F_DRN.n12 vss_1v2 0.06851f ; **FLOATING
C888 ota_cmfb_top_0.dynamic_pcell$5_0.F_DRN.n13 vss_1v2 0.1225f ; **FLOATING
C889 ota_cmfb_top_0.dynamic_pcell$5_0.F_DRN.n14 vss_1v2 0.33039f ; **FLOATING
C890 ota_cmfb_top_0.dynamic_pcell$5_0.F_DRN.n15 vss_1v2 0.43319f ; **FLOATING
C891 ota_cmfb_top_0.dynamic_pcell$5_0.F_DRN.n16 vss_1v2 0.44948f ; **FLOATING
C892 ota_cmfb_top_0.dynamic_pcell$5_0.F_DRN.n17 vss_1v2 0.43319f ; **FLOATING
C893 ota_cmfb_top_0.dynamic_pcell$5_0.F_DRN.n18 vss_1v2 0.44161f ; **FLOATING
C894 ota_cmfb_top_0.dynamic_pcell$5_0.F_DRN.n19 vss_1v2 0.43319f ; **FLOATING
C895 ota_cmfb_top_0.dynamic_pcell$5_0.F_DRN.n20 vss_1v2 0.43319f ; **FLOATING
C896 ota_cmfb_top_0.dynamic_pcell$5_0.F_DRN.n21 vss_1v2 0.536f ; **FLOATING
C897 ota_cmfb_top_0.dynamic_pcell$5_0.F_DRN.n22 vss_1v2 0.54443f ; **FLOATING
C898 ota_cmfb_top_0.dynamic_pcell$5_0.F_DRN.n23 vss_1v2 0.1228f ; **FLOATING
C899 ota_cmfb_top_0.dynamic_pcell$5_0.F_DRN.n24 vss_1v2 0.02977f ; **FLOATING
C900 ota_cmfb_top_0.dynamic_pcell$5_0.F_DRN.n25 vss_1v2 0.02235f ; **FLOATING
C901 ota_cmfb_top_0.dynamic_pcell$5_0.F_DRN.t3 vss_1v2 0.069f ; **FLOATING
C902 ota_cmfb_top_0.dynamic_pcell$5_0.F_DRN.n26 vss_1v2 0.3946f ; **FLOATING
C903 ota_cmfb_top_0.dynamic_pcell$5_0.F_DRN.n27 vss_1v2 0.05472f ; **FLOATING
C904 ota_cmfb_top_0.dynamic_pcell$5_0.F_DRN.n28 vss_1v2 0.02235f ; **FLOATING
C905 ota_cmfb_top_0.dynamic_pcell$5_0.F_DRN.n29 vss_1v2 0.02977f ; **FLOATING
C906 ota_cmfb_top_0.dynamic_pcell$5_0.F_DRN.n30 vss_1v2 0.04261f ; **FLOATING
C907 ota_cmfb_top_0.dynamic_pcell$5_0.F_DRN.n31 vss_1v2 0.35669f ; **FLOATING
C908 ota_cmfb_top_0.dynamic_pcell$5_0.F_DRN.n32 vss_1v2 0.23696f ; **FLOATING
C909 ota_cmfb_top_0.dynamic_pcell$5_0.F_DRN.n33 vss_1v2 0.53578f ; **FLOATING
C910 ota_cmfb_top_0.dynamic_pcell$5_0.F_DRN.t7 vss_1v2 0.28218f ; **FLOATING
C911 ota_cmfb_top_0.dynamic_pcell$5_0.F_DRN.n34 vss_1v2 0.08091f ; **FLOATING
C912 ota_cmfb_top_0.dynamic_pcell$5_0.F_DRN.n35 vss_1v2 0.02977f ; **FLOATING
C913 ota_cmfb_top_0.dynamic_pcell$5_0.F_DRN.n36 vss_1v2 0.02818f ; **FLOATING
C914 ota_cmfb_top_0.dynamic_pcell$5_0.F_DRN.n37 vss_1v2 0.02235f ; **FLOATING
C915 ota_cmfb_top_0.dynamic_pcell$5_0.F_DRN.t5 vss_1v2 0.28218f ; **FLOATING
C916 ota_cmfb_top_0.dynamic_pcell$5_0.F_DRN.n38 vss_1v2 0.04473f ; **FLOATING
C917 ota_cmfb_top_0.dynamic_pcell$5_0.F_DRN.n39 vss_1v2 0.02977f ; **FLOATING
C918 ota_cmfb_top_0.dynamic_pcell$5_0.F_DRN.n40 vss_1v2 0.02977f ; **FLOATING
C919 ota_cmfb_top_0.dynamic_pcell$5_0.F_DRN.t4 vss_1v2 0.25889f ; **FLOATING
C920 ota_cmfb_top_0.dynamic_pcell$5_0.F_DRN.n41 vss_1v2 0.05485f ; **FLOATING
C921 ota_cmfb_top_0.dynamic_pcell$5_0.F_DRN.n42 vss_1v2 0.02235f ; **FLOATING
C922 ota_cmfb_top_0.dynamic_pcell$5_0.F_DRN.n43 vss_1v2 0.30483f ; **FLOATING
C923 ota_cmfb_top_0.dynamic_pcell$5_0.F_DRN.n44 vss_1v2 0.25971f ; **FLOATING
C924 ota_cmfb_top_0.dynamic_pcell$5_0.F_DRN.t2 vss_1v2 0.03903f ; **FLOATING
C925 ota_cmfb_top_0.dynamic_pcell$5_0.F_DRN.t1 vss_1v2 0.03957f ; **FLOATING
C926 ota_cmfb_top_0.dynamic_pcell$5_0.F_DRN.n45 vss_1v2 0.02977f ; **FLOATING
C927 ota_cmfb_top_0.dynamic_pcell$5_0.F_DRN.n46 vss_1v2 0.02235f ; **FLOATING
C928 ota_cmfb_top_0.dynamic_pcell$5_0.F_DRN.n47 vss_1v2 0.11447f ; **FLOATING
C929 ota_cmfb_top_0.dynamic_pcell$5_0.F_DRN.n48 vss_1v2 0.02235f ; **FLOATING
C930 ota_cmfb_top_0.dynamic_pcell$5_0.F_DRN.n49 vss_1v2 0.02977f ; **FLOATING
C931 ota_cmfb_top_0.dynamic_pcell$5_0.F_DRN.n50 vss_1v2 0.04261f ; **FLOATING
C932 ota_cmfb_top_0.dynamic_pcell$5_0.F_DRN.n51 vss_1v2 0.32803f ; **FLOATING
C933 ota_cmfb_top_0.dynamic_pcell$5_0.F_DRN.n52 vss_1v2 1.71969f ; **FLOATING
C934 ota_cmfb_top_0.dynamic_pcell$5_0.F_DRN.n53 vss_1v2 0.07301f ; **FLOATING
C935 ota_cmfb_top_0.dynamic_pcell$5_0.F_DRN.n54 vss_1v2 0.32049f ; **FLOATING
C936 ota_cmfb_top_0.dynamic_pcell$5_0.F_DRN.n55 vss_1v2 0.2957f ; **FLOATING
C937 ota_cmfb_top_0.dynamic_pcell$5_0.F_DRN.n56 vss_1v2 0.12281f ; **FLOATING
C938 ota_cmfb_top_0.dynamic_pcell$5_0.F_DRN.t12 vss_1v2 0.29305f ; **FLOATING
C939 ota_cmfb_top_0.dynamic_pcell$5_0.F_DRN.n57 vss_1v2 0.07823f ; **FLOATING
C940 ota_cmfb_top_0.dynamic_pcell$5_0.F_DRN.n58 vss_1v2 0.44507f ; **FLOATING
C941 ota_cmfb_top_0.dynamic_pcell$5_0.F_DRN.t10 vss_1v2 0.29305f ; **FLOATING
C942 ota_cmfb_top_0.dynamic_pcell$5_0.F_DRN.n59 vss_1v2 0.09648f ; **FLOATING
C943 ota_cmfb_top_0.dynamic_pcell$5_0.F_DRN.n60 vss_1v2 0.12285f ; **FLOATING
C944 ota_cmfb_top_0.dynamic_pcell$5_0.F_DRN.n61 vss_1v2 0.17728f ; **FLOATING
C945 ota_cmfb_top_0.dynamic_pcell$5_0.F_DRN.t0 vss_1v2 0.29305f ; **FLOATING
C946 ota_cmfb_top_0.dynamic_pcell$5_0.DRN_NET_E_GATE_CDEFGH.n0 vss_1v2 0.09347f ; **FLOATING
C947 ota_cmfb_top_0.dynamic_pcell$5_0.DRN_NET_E_GATE_CDEFGH.n1 vss_1v2 0.09347f ; **FLOATING
C948 ota_cmfb_top_0.dynamic_pcell$5_0.DRN_NET_E_GATE_CDEFGH.n2 vss_1v2 0.03831f ; **FLOATING
C949 ota_cmfb_top_0.dynamic_pcell$5_0.DRN_NET_E_GATE_CDEFGH.n3 vss_1v2 0.07897f ; **FLOATING
C950 ota_cmfb_top_0.dynamic_pcell$5_0.DRN_NET_E_GATE_CDEFGH.n4 vss_1v2 0.24099f ; **FLOATING
C951 ota_cmfb_top_0.dynamic_pcell$5_0.DRN_NET_E_GATE_CDEFGH.n5 vss_1v2 0.1342f ; **FLOATING
C952 ota_cmfb_top_0.dynamic_pcell$5_0.DRN_NET_E_GATE_CDEFGH.n6 vss_1v2 0.09213f ; **FLOATING
C953 ota_cmfb_top_0.dynamic_pcell$5_0.DRN_NET_E_GATE_CDEFGH.n7 vss_1v2 0.24099f ; **FLOATING
C954 ota_cmfb_top_0.dynamic_pcell$5_0.DRN_NET_E_GATE_CDEFGH.n8 vss_1v2 0.19975f ; **FLOATING
C955 ota_cmfb_top_0.dynamic_pcell$5_0.DRN_NET_E_GATE_CDEFGH.n9 vss_1v2 0.20359f ; **FLOATING
C956 ota_cmfb_top_0.dynamic_pcell$5_0.DRN_NET_E_GATE_CDEFGH.n10 vss_1v2 0.1836f ; **FLOATING
C957 ota_cmfb_top_0.dynamic_pcell$5_0.DRN_NET_E_GATE_CDEFGH.n11 vss_1v2 0.09213f ; **FLOATING
C958 ota_cmfb_top_0.dynamic_pcell$5_0.DRN_NET_E_GATE_CDEFGH.n12 vss_1v2 0.24099f ; **FLOATING
C959 ota_cmfb_top_0.dynamic_pcell$5_0.DRN_NET_E_GATE_CDEFGH.n13 vss_1v2 0.1342f ; **FLOATING
C960 ota_cmfb_top_0.dynamic_pcell$5_0.DRN_NET_E_GATE_CDEFGH.n14 vss_1v2 0.10581f ; **FLOATING
C961 ota_cmfb_top_0.dynamic_pcell$5_0.DRN_NET_E_GATE_CDEFGH.n15 vss_1v2 0.04273f ; **FLOATING
C962 ota_cmfb_top_0.dynamic_pcell$5_0.DRN_NET_E_GATE_CDEFGH.n16 vss_1v2 0.05902f ; **FLOATING
C963 ota_cmfb_top_0.dynamic_pcell$5_0.DRN_NET_E_GATE_CDEFGH.n17 vss_1v2 0.04273f ; **FLOATING
C964 ota_cmfb_top_0.dynamic_pcell$5_0.DRN_NET_E_GATE_CDEFGH.n18 vss_1v2 0.05902f ; **FLOATING
C965 ota_cmfb_top_0.dynamic_pcell$5_0.DRN_NET_E_GATE_CDEFGH.n19 vss_1v2 0.04019f ; **FLOATING
C966 ota_cmfb_top_0.dynamic_pcell$5_0.DRN_NET_E_GATE_CDEFGH.n20 vss_1v2 0.56903f ; **FLOATING
C967 ota_cmfb_top_0.dynamic_pcell$5_0.DRN_NET_E_GATE_CDEFGH.n21 vss_1v2 0.12528f ; **FLOATING
C968 ota_cmfb_top_0.dynamic_pcell$5_0.DRN_NET_E_GATE_CDEFGH.n22 vss_1v2 0.04019f ; **FLOATING
C969 ota_cmfb_top_0.dynamic_pcell$5_0.DRN_NET_E_GATE_CDEFGH.n23 vss_1v2 0.05578f ; **FLOATING
C970 ota_cmfb_top_0.dynamic_pcell$5_0.DRN_NET_E_GATE_CDEFGH.n24 vss_1v2 0.04273f ; **FLOATING
C971 ota_cmfb_top_0.dynamic_pcell$5_0.DRN_NET_E_GATE_CDEFGH.n25 vss_1v2 0.05902f ; **FLOATING
C972 ota_cmfb_top_0.dynamic_pcell$5_0.DRN_NET_E_GATE_CDEFGH.n26 vss_1v2 0.04273f ; **FLOATING
C973 ota_cmfb_top_0.dynamic_pcell$5_0.DRN_NET_E_GATE_CDEFGH.n27 vss_1v2 0.05902f ; **FLOATING
C974 ota_cmfb_top_0.dynamic_pcell$5_0.DRN_NET_E_GATE_CDEFGH.n28 vss_1v2 0.08403f ; **FLOATING
C975 ota_cmfb_top_0.dynamic_pcell$5_0.DRN_NET_E_GATE_CDEFGH.n29 vss_1v2 0.04273f ; **FLOATING
C976 ota_cmfb_top_0.dynamic_pcell$5_0.DRN_NET_E_GATE_CDEFGH.n30 vss_1v2 0.05902f ; **FLOATING
C977 ota_cmfb_top_0.dynamic_pcell$5_0.DRN_NET_E_GATE_CDEFGH.n31 vss_1v2 0.04273f ; **FLOATING
C978 ota_cmfb_top_0.dynamic_pcell$5_0.DRN_NET_E_GATE_CDEFGH.n32 vss_1v2 0.05902f ; **FLOATING
C979 ota_cmfb_top_0.dynamic_pcell$5_0.DRN_NET_E_GATE_CDEFGH.n33 vss_1v2 0.04019f ; **FLOATING
C980 ota_cmfb_top_0.dynamic_pcell$5_0.DRN_NET_E_GATE_CDEFGH.n34 vss_1v2 0.56902f ; **FLOATING
C981 ota_cmfb_top_0.dynamic_pcell$5_0.DRN_NET_E_GATE_CDEFGH.n35 vss_1v2 0.12528f ; **FLOATING
C982 ota_cmfb_top_0.dynamic_pcell$5_0.DRN_NET_E_GATE_CDEFGH.n36 vss_1v2 0.04019f ; **FLOATING
C983 ota_cmfb_top_0.dynamic_pcell$5_0.DRN_NET_E_GATE_CDEFGH.n37 vss_1v2 0.32193f ; **FLOATING
C984 ota_cmfb_top_0.dynamic_pcell$5_0.DRN_NET_E_GATE_CDEFGH.n38 vss_1v2 0.12529f ; **FLOATING
C985 ota_cmfb_top_0.dynamic_pcell$5_0.DRN_NET_E_GATE_CDEFGH.n39 vss_1v2 0.04019f ; **FLOATING
C986 ota_cmfb_top_0.dynamic_pcell$5_0.DRN_NET_E_GATE_CDEFGH.n40 vss_1v2 0.08429f ; **FLOATING
C987 ota_cmfb_top_0.dynamic_pcell$5_0.DRN_NET_E_GATE_CDEFGH.n41 vss_1v2 0.04019f ; **FLOATING
C988 ota_cmfb_top_0.dynamic_pcell$5_0.DRN_NET_E_GATE_CDEFGH.n42 vss_1v2 0.08429f ; **FLOATING
C989 ota_cmfb_top_0.dynamic_pcell$5_0.DRN_NET_E_GATE_CDEFGH.n43 vss_1v2 0.04019f ; **FLOATING
C990 ota_cmfb_top_0.dynamic_pcell$5_0.DRN_NET_E_GATE_CDEFGH.n44 vss_1v2 0.4455f ; **FLOATING
C991 ota_cmfb_top_0.dynamic_pcell$5_0.DRN_NET_E_GATE_CDEFGH.n45 vss_1v2 0.12526f ; **FLOATING
C992 ota_cmfb_top_0.dynamic_pcell$5_0.DRN_NET_E_GATE_CDEFGH.n46 vss_1v2 0.04019f ; **FLOATING
C993 ota_cmfb_top_0.dynamic_pcell$5_0.DRN_NET_E_GATE_CDEFGH.n47 vss_1v2 0.44551f ; **FLOATING
C994 ota_cmfb_top_0.dynamic_pcell$5_0.DRN_NET_E_GATE_CDEFGH.n48 vss_1v2 0.12527f ; **FLOATING
C995 ota_cmfb_top_0.dynamic_pcell$5_0.DRN_NET_E_GATE_CDEFGH.n49 vss_1v2 0.04408f ; **FLOATING
C996 ota_cmfb_top_0.dynamic_pcell$5_0.DRN_NET_E_GATE_CDEFGH.n50 vss_1v2 0.07911f ; **FLOATING
C997 ota_cmfb_top_0.dynamic_pcell$5_0.DRN_NET_E_GATE_CDEFGH.n51 vss_1v2 0.07911f ; **FLOATING
C998 ota_cmfb_top_0.dynamic_pcell$5_0.DRN_NET_E_GATE_CDEFGH.n52 vss_1v2 0.04019f ; **FLOATING
C999 ota_cmfb_top_0.dynamic_pcell$5_0.DRN_NET_E_GATE_CDEFGH.n53 vss_1v2 0.05578f ; **FLOATING
C1000 ota_cmfb_top_0.dynamic_pcell$5_0.DRN_NET_E_GATE_CDEFGH.n54 vss_1v2 0.24099f ; **FLOATING
C1001 ota_cmfb_top_0.dynamic_pcell$5_0.DRN_NET_E_GATE_CDEFGH.n55 vss_1v2 0.07288f ; **FLOATING
C1002 ota_cmfb_top_0.dynamic_pcell$5_0.DRN_NET_E_GATE_CDEFGH.n56 vss_1v2 0.24099f ; **FLOATING
C1003 ota_cmfb_top_0.dynamic_pcell$5_0.DRN_NET_E_GATE_CDEFGH.n57 vss_1v2 0.07288f ; **FLOATING
C1004 ota_cmfb_top_0.dynamic_pcell$5_0.DRN_NET_E_GATE_CDEFGH.n58 vss_1v2 0.04408f ; **FLOATING
C1005 ota_cmfb_top_0.dynamic_pcell$5_0.DRN_NET_E_GATE_CDEFGH.n59 vss_1v2 0.04408f ; **FLOATING
C1006 ota_cmfb_top_0.dynamic_pcell$5_0.DRN_NET_E_GATE_CDEFGH.n60 vss_1v2 0.08999f ; **FLOATING
C1007 ota_cmfb_top_0.dynamic_pcell$5_0.DRN_NET_E_GATE_CDEFGH.n61 vss_1v2 0.05972f ; **FLOATING
C1008 ota_cmfb_top_0.dynamic_pcell$5_0.DRN_NET_E_GATE_CDEFGH.n62 vss_1v2 0.08999f ; **FLOATING
C1009 ota_cmfb_top_0.dynamic_pcell$5_0.DRN_NET_E_GATE_CDEFGH.n63 vss_1v2 0.05972f ; **FLOATING
C1010 ota_cmfb_top_0.dynamic_pcell$5_0.DRN_NET_E_GATE_CDEFGH.t4 vss_1v2 0.41594f ; **FLOATING
C1011 ota_cmfb_top_0.dynamic_pcell$5_0.DRN_NET_E_GATE_CDEFGH.n64 vss_1v2 0.75804f ; **FLOATING
C1012 ota_cmfb_top_0.dynamic_pcell$5_0.DRN_NET_E_GATE_CDEFGH.t10 vss_1v2 0.83873f ; **FLOATING
C1013 ota_cmfb_top_0.dynamic_pcell$5_0.DRN_NET_E_GATE_CDEFGH.t11 vss_1v2 0.83024f ; **FLOATING
C1014 ota_cmfb_top_0.dynamic_pcell$5_0.DRN_NET_E_GATE_CDEFGH.n65 vss_1v2 0.13963f ; **FLOATING
C1015 ota_cmfb_top_0.dynamic_pcell$5_0.DRN_NET_E_GATE_CDEFGH.t9 vss_1v2 0.83877f ; **FLOATING
C1016 ota_cmfb_top_0.dynamic_pcell$5_0.DRN_NET_E_GATE_CDEFGH.t0 vss_1v2 0.77714f ; **FLOATING
C1017 ota_cmfb_top_0.dynamic_pcell$5_0.DRN_NET_E_GATE_CDEFGH.t1 vss_1v2 0.01625f ; **FLOATING
C1018 ota_cmfb_top_0.dynamic_pcell$5_0.DRN_NET_E_GATE_CDEFGH.n66 vss_1v2 0.17374f ; **FLOATING
C1019 ota_cmfb_top_0.dynamic_pcell$5_0.DRN_NET_E_GATE_CDEFGH.n67 vss_1v2 0.09615f ; **FLOATING
C1020 ota_cmfb_top_0.dynamic_pcell$5_0.DRN_NET_E_GATE_CDEFGH.t5 vss_1v2 0.03435f ; **FLOATING
C1021 ota_cmfb_top_0.dynamic_pcell$5_0.DRN_NET_E_GATE_CDEFGH.n68 vss_1v2 0.16521f ; **FLOATING
C1022 ota_cmfb_top_0.dynamic_pcell$5_0.DRN_NET_E_GATE_CDEFGH.t6 vss_1v2 0.83874f ; **FLOATING
C1023 ota_cmfb_top_0.dynamic_pcell$5_0.DRN_NET_E_GATE_CDEFGH.t7 vss_1v2 0.83252f ; **FLOATING
C1024 ota_cmfb_top_0.dynamic_pcell$5_0.DRN_NET_E_GATE_CDEFGH.n69 vss_1v2 0.1486f ; **FLOATING
C1025 ota_cmfb_top_0.dynamic_pcell$5_0.DRN_NET_E_GATE_CDEFGH.t3 vss_1v2 0.01634f ; **FLOATING
C1026 ota_cmfb_top_0.dynamic_pcell$5_0.DRN_NET_E_GATE_CDEFGH.t2 vss_1v2 0.82281f ; **FLOATING
C1027 ota_cmfb_top_0.dynamic_pcell$5_0.DRN_NET_E_GATE_CDEFGH.t8 vss_1v2 0.83359f ; **FLOATING
C1028 ota_cmfb_top_0.dynamic_pcell$5_0.DRN_NET_E_GATE_CDEFGH.n70 vss_1v2 0.12914f ; **FLOATING
C1029 vdd_1v2.n7 vss_1v2 0.02728f ; **FLOATING
C1030 vdd_1v2.n14 vss_1v2 0.04745f ; **FLOATING
C1031 vdd_1v2.n15 vss_1v2 0.08325f ; **FLOATING
C1032 vdd_1v2.n37 vss_1v2 0.01092f ; **FLOATING
C1033 vdd_1v2.n38 vss_1v2 0.01149f ; **FLOATING
C1034 vdd_1v2.t0 vss_1v2 0.29471p ; **FLOATING
C1035 vdd_1v2.n43 vss_1v2 0.03216f ; **FLOATING
C1036 vdd_1v2.t230 vss_1v2 0.01209f ; **FLOATING
C1037 vdd_1v2.t392 vss_1v2 0.01366f ; **FLOATING
C1038 vdd_1v2.t206 vss_1v2 0.01127f ; **FLOATING
C1039 vdd_1v2.n45 vss_1v2 0.03615f ; **FLOATING
C1040 vdd_1v2.n46 vss_1v2 0.02263f ; **FLOATING
C1041 vdd_1v2.n47 vss_1v2 0.01959f ; **FLOATING
C1042 vdd_1v2.t347 vss_1v2 0.01196f ; **FLOATING
C1043 vdd_1v2.n51 vss_1v2 0.0273f ; **FLOATING
C1044 vdd_1v2.n53 vss_1v2 0.05536f ; **FLOATING
C1045 vdd_1v2.n55 vss_1v2 0.13072f ; **FLOATING
C1046 vdd_1v2.n56 vss_1v2 0.02928f ; **FLOATING
C1047 vdd_1v2.n57 vss_1v2 0.01578f ; **FLOATING
C1048 vdd_1v2.n58 vss_1v2 0.06042f ; **FLOATING
C1049 vdd_1v2.n59 vss_1v2 0.01826f ; **FLOATING
C1050 vdd_1v2.n60 vss_1v2 0.04573f ; **FLOATING
C1051 vdd_1v2.n61 vss_1v2 0.01943f ; **FLOATING
C1052 vdd_1v2.t58 vss_1v2 0.01361f ; **FLOATING
C1053 vdd_1v2.t55 vss_1v2 0.01357f ; **FLOATING
C1054 vdd_1v2.t52 vss_1v2 0.01357f ; **FLOATING
C1055 vdd_1v2.t49 vss_1v2 0.01357f ; **FLOATING
C1056 vdd_1v2.t46 vss_1v2 0.01357f ; **FLOATING
C1057 vdd_1v2.t43 vss_1v2 0.01357f ; **FLOATING
C1058 vdd_1v2.t40 vss_1v2 0.01357f ; **FLOATING
C1059 vdd_1v2.t38 vss_1v2 0.0136f ; **FLOATING
C1060 vdd_1v2.t104 vss_1v2 0.01589f ; **FLOATING
C1061 vdd_1v2.t458 vss_1v2 0.01208f ; **FLOATING
C1062 vdd_1v2.n79 vss_1v2 0.05004f ; **FLOATING
C1063 vdd_1v2.t23 vss_1v2 0.01208f ; **FLOATING
C1064 vdd_1v2.n80 vss_1v2 0.0497f ; **FLOATING
C1065 vdd_1v2.t111 vss_1v2 0.01361f ; **FLOATING
C1066 vdd_1v2.t61 vss_1v2 0.01357f ; **FLOATING
C1067 vdd_1v2.t100 vss_1v2 0.01357f ; **FLOATING
C1068 vdd_1v2.t98 vss_1v2 0.01357f ; **FLOATING
C1069 vdd_1v2.t96 vss_1v2 0.01357f ; **FLOATING
C1070 vdd_1v2.t94 vss_1v2 0.01357f ; **FLOATING
C1071 vdd_1v2.t92 vss_1v2 0.01357f ; **FLOATING
C1072 vdd_1v2.t89 vss_1v2 0.01357f ; **FLOATING
C1073 vdd_1v2.t60 vss_1v2 0.14746f ; **FLOATING
C1074 vdd_1v2.n119 vss_1v2 0.01322f ; **FLOATING
C1075 vdd_1v2.t67 vss_1v2 0.01361f ; **FLOATING
C1076 vdd_1v2.t69 vss_1v2 0.01357f ; **FLOATING
C1077 vdd_1v2.t72 vss_1v2 0.01357f ; **FLOATING
C1078 vdd_1v2.t75 vss_1v2 0.01357f ; **FLOATING
C1079 vdd_1v2.t78 vss_1v2 0.01357f ; **FLOATING
C1080 vdd_1v2.t81 vss_1v2 0.01357f ; **FLOATING
C1081 vdd_1v2.t84 vss_1v2 0.01357f ; **FLOATING
C1082 vdd_1v2.t87 vss_1v2 0.01357f ; **FLOATING
C1083 vdd_1v2.t102 vss_1v2 0.01361f ; **FLOATING
C1084 vdd_1v2.t113 vss_1v2 0.01357f ; **FLOATING
C1085 vdd_1v2.t105 vss_1v2 0.01357f ; **FLOATING
C1086 vdd_1v2.t115 vss_1v2 0.01357f ; **FLOATING
C1087 vdd_1v2.t118 vss_1v2 0.01357f ; **FLOATING
C1088 vdd_1v2.t121 vss_1v2 0.01357f ; **FLOATING
C1089 vdd_1v2.t124 vss_1v2 0.01357f ; **FLOATING
C1090 vdd_1v2.t126 vss_1v2 0.01362f ; **FLOATING
C1091 vdd_1v2.t242 vss_1v2 0.01171f ; **FLOATING
C1092 vdd_1v2.n154 vss_1v2 0.03209f ; **FLOATING
C1093 vdd_1v2.t239 vss_1v2 0.01309f ; **FLOATING
C1094 vdd_1v2.t237 vss_1v2 0.02222f ; **FLOATING
C1095 vdd_1v2.t240 vss_1v2 0.02219f ; **FLOATING
C1096 vdd_1v2.t233 vss_1v2 0.01171f ; **FLOATING
C1097 vdd_1v2.t232 vss_1v2 0.01309f ; **FLOATING
C1098 vdd_1v2.t234 vss_1v2 0.02222f ; **FLOATING
C1099 vdd_1v2.t231 vss_1v2 0.02219f ; **FLOATING
C1100 vdd_1v2.t227 vss_1v2 0.01309f ; **FLOATING
C1101 vdd_1v2.t225 vss_1v2 0.02222f ; **FLOATING
C1102 vdd_1v2.t228 vss_1v2 0.02219f ; **FLOATING
C1103 vdd_1v2.t218 vss_1v2 0.01171f ; **FLOATING
C1104 vdd_1v2.t215 vss_1v2 0.01309f ; **FLOATING
C1105 vdd_1v2.t213 vss_1v2 0.02222f ; **FLOATING
C1106 vdd_1v2.t216 vss_1v2 0.02219f ; **FLOATING
C1107 vdd_1v2.t209 vss_1v2 0.01171f ; **FLOATING
C1108 vdd_1v2.t208 vss_1v2 0.01309f ; **FLOATING
C1109 vdd_1v2.t210 vss_1v2 0.02222f ; **FLOATING
C1110 vdd_1v2.t207 vss_1v2 0.02219f ; **FLOATING
C1111 vdd_1v2.t238 vss_1v2 0.01838f ; **FLOATING
C1112 vdd_1v2.n192 vss_1v2 0.02421f ; **FLOATING
C1113 vdd_1v2.t226 vss_1v2 0.0131f ; **FLOATING
C1114 vdd_1v2.n199 vss_1v2 0.01402f ; **FLOATING
C1115 vdd_1v2.t214 vss_1v2 0.0131f ; **FLOATING
C1116 vdd_1v2.n206 vss_1v2 0.01272f ; **FLOATING
C1117 vdd_1v2.t202 vss_1v2 0.0131f ; **FLOATING
C1118 vdd_1v2.t236 vss_1v2 0.01838f ; **FLOATING
C1119 vdd_1v2.t224 vss_1v2 0.0131f ; **FLOATING
C1120 vdd_1v2.t212 vss_1v2 0.0131f ; **FLOATING
C1121 vdd_1v2.n234 vss_1v2 0.0149f ; **FLOATING
C1122 vdd_1v2.t200 vss_1v2 0.0131f ; **FLOATING
C1123 vdd_1v2.n240 vss_1v2 0.03375f ; **FLOATING
C1124 vdd_1v2.n241 vss_1v2 0.03728f ; **FLOATING
C1125 vdd_1v2.t203 vss_1v2 0.01288f ; **FLOATING
C1126 vdd_1v2.t201 vss_1v2 0.02222f ; **FLOATING
C1127 vdd_1v2.t204 vss_1v2 0.02219f ; **FLOATING
C1128 vdd_1v2.t221 vss_1v2 0.01171f ; **FLOATING
C1129 vdd_1v2.t220 vss_1v2 0.01309f ; **FLOATING
C1130 vdd_1v2.t222 vss_1v2 0.02225f ; **FLOATING
C1131 vdd_1v2.t219 vss_1v2 0.02219f ; **FLOATING
C1132 vdd_1v2.t139 vss_1v2 0.01171f ; **FLOATING
C1133 vdd_1v2.t138 vss_1v2 0.01309f ; **FLOATING
C1134 vdd_1v2.t140 vss_1v2 0.02222f ; **FLOATING
C1135 vdd_1v2.t137 vss_1v2 0.02219f ; **FLOATING
C1136 vdd_1v2.t110 vss_1v2 0.01171f ; **FLOATING
C1137 vdd_1v2.t35 vss_1v2 0.01309f ; **FLOATING
C1138 vdd_1v2.t34 vss_1v2 0.02222f ; **FLOATING
C1139 vdd_1v2.t108 vss_1v2 0.02219f ; **FLOATING
C1140 vdd_1v2.t136 vss_1v2 0.01171f ; **FLOATING
C1141 vdd_1v2.n266 vss_1v2 0.03916f ; **FLOATING
C1142 vdd_1v2.t134 vss_1v2 0.01309f ; **FLOATING
C1143 vdd_1v2.t133 vss_1v2 0.02222f ; **FLOATING
C1144 vdd_1v2.t135 vss_1v2 0.02219f ; **FLOATING
C1145 vdd_1v2.t143 vss_1v2 0.01171f ; **FLOATING
C1146 vdd_1v2.t131 vss_1v2 0.02222f ; **FLOATING
C1147 vdd_1v2.t132 vss_1v2 0.01309f ; **FLOATING
C1148 vdd_1v2.t142 vss_1v2 0.02219f ; **FLOATING
C1149 vdd_1v2.t149 vss_1v2 0.01171f ; **FLOATING
C1150 vdd_1v2.t148 vss_1v2 0.02219f ; **FLOATING
C1151 vdd_1v2.t36 vss_1v2 0.02225f ; **FLOATING
C1152 vdd_1v2.t37 vss_1v2 0.01309f ; **FLOATING
C1153 vdd_1v2.t197 vss_1v2 0.01309f ; **FLOATING
C1154 vdd_1v2.t199 vss_1v2 0.02222f ; **FLOATING
C1155 vdd_1v2.t196 vss_1v2 0.02219f ; **FLOATING
C1156 vdd_1v2.t198 vss_1v2 0.01171f ; **FLOATING
C1157 vdd_1v2.t130 vss_1v2 0.01171f ; **FLOATING
C1158 vdd_1v2.t129 vss_1v2 0.01309f ; **FLOATING
C1159 vdd_1v2.t144 vss_1v2 0.02222f ; **FLOATING
C1160 vdd_1v2.t128 vss_1v2 0.02219f ; **FLOATING
C1161 vdd_1v2.t163 vss_1v2 0.01171f ; **FLOATING
C1162 vdd_1v2.t147 vss_1v2 0.01309f ; **FLOATING
C1163 vdd_1v2.t146 vss_1v2 0.02222f ; **FLOATING
C1164 vdd_1v2.t161 vss_1v2 0.02219f ; **FLOATING
C1165 vdd_1v2.t152 vss_1v2 0.01171f ; **FLOATING
C1166 vdd_1v2.t151 vss_1v2 0.01309f ; **FLOATING
C1167 vdd_1v2.t159 vss_1v2 0.02222f ; **FLOATING
C1168 vdd_1v2.t150 vss_1v2 0.02219f ; **FLOATING
C1169 vdd_1v2.n308 vss_1v2 0.08148f ; **FLOATING
C1170 vdd_1v2.n310 vss_1v2 0.02169f ; **FLOATING
C1171 vdd_1v2.t153 vss_1v2 0.07494f ; **FLOATING
C1172 vdd_1v2.n332 vss_1v2 0.01358f ; **FLOATING
C1173 vdd_1v2.n335 vss_1v2 0.01358f ; **FLOATING
C1174 vdd_1v2.t177 vss_1v2 0.07494f ; **FLOATING
C1175 vdd_1v2.t288 vss_1v2 0.01171f ; **FLOATING
C1176 vdd_1v2.t287 vss_1v2 0.01309f ; **FLOATING
C1177 vdd_1v2.t289 vss_1v2 0.02305f ; **FLOATING
C1178 vdd_1v2.t286 vss_1v2 0.02302f ; **FLOATING
C1179 vdd_1v2.t277 vss_1v2 0.01171f ; **FLOATING
C1180 vdd_1v2.t276 vss_1v2 0.01309f ; **FLOATING
C1181 vdd_1v2.t278 vss_1v2 0.02305f ; **FLOATING
C1182 vdd_1v2.t275 vss_1v2 0.02302f ; **FLOATING
C1183 vdd_1v2.t296 vss_1v2 0.01171f ; **FLOATING
C1184 vdd_1v2.t295 vss_1v2 0.01309f ; **FLOATING
C1185 vdd_1v2.t299 vss_1v2 0.02305f ; **FLOATING
C1186 vdd_1v2.t294 vss_1v2 0.02302f ; **FLOATING
C1187 vdd_1v2.t310 vss_1v2 0.01171f ; **FLOATING
C1188 vdd_1v2.t309 vss_1v2 0.01309f ; **FLOATING
C1189 vdd_1v2.t311 vss_1v2 0.02305f ; **FLOATING
C1190 vdd_1v2.t308 vss_1v2 0.02302f ; **FLOATING
C1191 vdd_1v2.n371 vss_1v2 0.01099f ; **FLOATING
C1192 vdd_1v2.t318 vss_1v2 0.01171f ; **FLOATING
C1193 vdd_1v2.t317 vss_1v2 0.01309f ; **FLOATING
C1194 vdd_1v2.t319 vss_1v2 0.02305f ; **FLOATING
C1195 vdd_1v2.n377 vss_1v2 0.01032f ; **FLOATING
C1196 vdd_1v2.t316 vss_1v2 0.02302f ; **FLOATING
C1197 vdd_1v2.n381 vss_1v2 0.027f ; **FLOATING
C1198 vdd_1v2.t3 vss_1v2 0.02112f ; **FLOATING
C1199 vdd_1v2.n385 vss_1v2 0.01939f ; **FLOATING
C1200 vdd_1v2.t1 vss_1v2 0.0131f ; **FLOATING
C1201 vdd_1v2.t7 vss_1v2 0.01974f ; **FLOATING
C1202 vdd_1v2.n396 vss_1v2 0.01939f ; **FLOATING
C1203 vdd_1v2.t2 vss_1v2 0.01172f ; **FLOATING
C1204 vdd_1v2.n400 vss_1v2 0.03173f ; **FLOATING
C1205 vdd_1v2.t5 vss_1v2 0.02618f ; **FLOATING
C1206 vdd_1v2.n401 vss_1v2 0.04264f ; **FLOATING
C1207 vdd_1v2.t8 vss_1v2 0.02871f ; **FLOATING
C1208 vdd_1v2.t11 vss_1v2 0.02618f ; **FLOATING
C1209 vdd_1v2.n402 vss_1v2 0.03653f ; **FLOATING
C1210 vdd_1v2.t13 vss_1v2 0.02618f ; **FLOATING
C1211 vdd_1v2.n403 vss_1v2 0.0182f ; **FLOATING
C1212 vdd_1v2.n404 vss_1v2 0.01334f ; **FLOATING
C1213 vdd_1v2.n405 vss_1v2 0.03602f ; **FLOATING
C1214 vdd_1v2.t9 vss_1v2 0.03132f ; **FLOATING
C1215 vdd_1v2.t14 vss_1v2 0.02867f ; **FLOATING
C1216 vdd_1v2.n406 vss_1v2 0.03903f ; **FLOATING
C1217 vdd_1v2.t17 vss_1v2 0.02729f ; **FLOATING
C1218 vdd_1v2.n407 vss_1v2 0.03399f ; **FLOATING
C1219 vdd_1v2.n408 vss_1v2 0.01922f ; **FLOATING
C1220 vdd_1v2.n409 vss_1v2 0.02509f ; **FLOATING
C1221 vdd_1v2.t19 vss_1v2 0.03113f ; **FLOATING
C1222 vdd_1v2.n410 vss_1v2 0.03961f ; **FLOATING
C1223 vdd_1v2.n415 vss_1v2 0.01329f ; **FLOATING
C1224 vdd_1v2.t21 vss_1v2 0.0165f ; **FLOATING
C1225 vdd_1v2.n421 vss_1v2 0.01759f ; **FLOATING
C1226 vdd_1v2.t4 vss_1v2 0.01172f ; **FLOATING
C1227 vdd_1v2.n426 vss_1v2 0.02052f ; **FLOATING
C1228 vdd_1v2.t18 vss_1v2 0.0131f ; **FLOATING
C1229 vdd_1v2.t22 vss_1v2 0.01787f ; **FLOATING
C1230 vdd_1v2.n432 vss_1v2 0.01759f ; **FLOATING
C1231 vdd_1v2.n433 vss_1v2 0.01285f ; **FLOATING
C1232 vdd_1v2.n434 vss_1v2 0.01521f ; **FLOATING
C1233 vdd_1v2.t390 vss_1v2 0.01171f ; **FLOATING
C1234 vdd_1v2.t389 vss_1v2 0.01309f ; **FLOATING
C1235 vdd_1v2.t394 vss_1v2 0.02305f ; **FLOATING
C1236 vdd_1v2.t328 vss_1v2 0.01366f ; **FLOATING
C1237 vdd_1v2.t327 vss_1v2 0.02311f ; **FLOATING
C1238 vdd_1v2.t345 vss_1v2 0.02302f ; **FLOATING
C1239 vdd_1v2.t388 vss_1v2 0.02302f ; **FLOATING
C1240 vdd_1v2.t326 vss_1v2 0.01171f ; **FLOATING
C1241 vdd_1v2.t325 vss_1v2 0.01309f ; **FLOATING
C1242 vdd_1v2.t343 vss_1v2 0.02305f ; **FLOATING
C1243 vdd_1v2.n446 vss_1v2 0.02643f ; **FLOATING
C1244 vdd_1v2.t324 vss_1v2 0.02302f ; **FLOATING
C1245 vdd_1v2.t372 vss_1v2 0.01171f ; **FLOATING
C1246 vdd_1v2.t371 vss_1v2 0.01309f ; **FLOATING
C1247 vdd_1v2.t381 vss_1v2 0.02305f ; **FLOATING
C1248 vdd_1v2.t370 vss_1v2 0.02302f ; **FLOATING
C1249 vdd_1v2.t334 vss_1v2 0.01171f ; **FLOATING
C1250 vdd_1v2.t333 vss_1v2 0.01309f ; **FLOATING
C1251 vdd_1v2.t360 vss_1v2 0.02305f ; **FLOATING
C1252 vdd_1v2.t332 vss_1v2 0.02302f ; **FLOATING
C1253 vdd_1v2.t64 vss_1v2 0.07494f ; **FLOATING
C1254 vdd_1v2.n486 vss_1v2 0.01358f ; **FLOATING
C1255 vdd_1v2.n489 vss_1v2 0.01358f ; **FLOATING
C1256 vdd_1v2.t258 vss_1v2 0.07494f ; **FLOATING
C1257 vdd_1v2.t355 vss_1v2 0.01171f ; **FLOATING
C1258 vdd_1v2.t357 vss_1v2 0.02305f ; **FLOATING
C1259 vdd_1v2.t356 vss_1v2 0.01309f ; **FLOATING
C1260 vdd_1v2.t292 vss_1v2 0.01309f ; **FLOATING
C1261 vdd_1v2.t297 vss_1v2 0.02305f ; **FLOATING
C1262 vdd_1v2.t291 vss_1v2 0.02302f ; **FLOATING
C1263 vdd_1v2.t293 vss_1v2 0.01171f ; **FLOATING
C1264 vdd_1v2.t354 vss_1v2 0.02302f ; **FLOATING
C1265 vdd_1v2.t285 vss_1v2 0.01171f ; **FLOATING
C1266 vdd_1v2.n513 vss_1v2 0.01195f ; **FLOATING
C1267 vdd_1v2.t282 vss_1v2 0.02305f ; **FLOATING
C1268 vdd_1v2.t283 vss_1v2 0.01309f ; **FLOATING
C1269 vdd_1v2.t284 vss_1v2 0.02302f ; **FLOATING
C1270 vdd_1v2.t350 vss_1v2 0.01171f ; **FLOATING
C1271 vdd_1v2.t349 vss_1v2 0.01309f ; **FLOATING
C1272 vdd_1v2.t351 vss_1v2 0.02305f ; **FLOATING
C1273 vdd_1v2.t348 vss_1v2 0.02302f ; **FLOATING
C1274 vdd_1v2.t330 vss_1v2 0.01309f ; **FLOATING
C1275 vdd_1v2.t341 vss_1v2 0.02305f ; **FLOATING
C1276 vdd_1v2.t329 vss_1v2 0.02302f ; **FLOATING
C1277 vdd_1v2.n530 vss_1v2 0.01516f ; **FLOATING
C1278 vdd_1v2.t331 vss_1v2 0.01171f ; **FLOATING
C1279 vdd_1v2.t368 vss_1v2 0.01171f ; **FLOATING
C1280 vdd_1v2.t379 vss_1v2 0.02305f ; **FLOATING
C1281 vdd_1v2.t369 vss_1v2 0.01309f ; **FLOATING
C1282 vdd_1v2.t367 vss_1v2 0.02302f ; **FLOATING
C1283 vdd_1v2.t307 vss_1v2 0.01309f ; **FLOATING
C1284 vdd_1v2.t306 vss_1v2 0.02305f ; **FLOATING
C1285 vdd_1v2.t313 vss_1v2 0.02302f ; **FLOATING
C1286 vdd_1v2.t315 vss_1v2 0.01171f ; **FLOATING
C1287 vdd_1v2.t336 vss_1v2 0.01171f ; **FLOATING
C1288 vdd_1v2.t362 vss_1v2 0.02305f ; **FLOATING
C1289 vdd_1v2.t337 vss_1v2 0.01309f ; **FLOATING
C1290 vdd_1v2.t335 vss_1v2 0.02302f ; **FLOATING
C1291 vdd_1v2.t302 vss_1v2 0.01309f ; **FLOATING
C1292 vdd_1v2.t301 vss_1v2 0.02305f ; **FLOATING
C1293 vdd_1v2.t303 vss_1v2 0.02302f ; **FLOATING
C1294 vdd_1v2.t305 vss_1v2 0.01171f ; **FLOATING
C1295 vdd_1v2.t339 vss_1v2 0.01309f ; **FLOATING
C1296 vdd_1v2.t338 vss_1v2 0.02305f ; **FLOATING
C1297 vdd_1v2.t364 vss_1v2 0.02302f ; **FLOATING
C1298 vdd_1v2.t366 vss_1v2 0.01171f ; **FLOATING
C1299 vdd_1v2.t374 vss_1v2 0.01171f ; **FLOATING
C1300 vdd_1v2.t383 vss_1v2 0.02305f ; **FLOATING
C1301 vdd_1v2.t375 vss_1v2 0.01309f ; **FLOATING
C1302 vdd_1v2.t373 vss_1v2 0.02302f ; **FLOATING
C1303 vdd_1v2.t281 vss_1v2 0.01309f ; **FLOATING
C1304 vdd_1v2.t280 vss_1v2 0.02305f ; **FLOATING
C1305 vdd_1v2.t321 vss_1v2 0.02302f ; **FLOATING
C1306 vdd_1v2.t323 vss_1v2 0.01171f ; **FLOATING
C1307 vdd_1v2.t377 vss_1v2 0.01309f ; **FLOATING
C1308 vdd_1v2.t376 vss_1v2 0.02305f ; **FLOATING
C1309 vdd_1v2.t385 vss_1v2 0.02302f ; **FLOATING
C1310 vdd_1v2.t387 vss_1v2 0.01171f ; **FLOATING
C1311 vdd_1v2.t359 vss_1v2 0.02112f ; **FLOATING
C1312 vdd_1v2.n588 vss_1v2 0.01939f ; **FLOATING
C1313 vdd_1v2.t353 vss_1v2 0.0131f ; **FLOATING
C1314 vdd_1v2.t437 vss_1v2 0.01974f ; **FLOATING
C1315 vdd_1v2.n599 vss_1v2 0.01939f ; **FLOATING
C1316 vdd_1v2.t432 vss_1v2 0.01172f ; **FLOATING
C1317 vdd_1v2.n603 vss_1v2 0.03173f ; **FLOATING
C1318 vdd_1v2.t433 vss_1v2 0.02618f ; **FLOATING
C1319 vdd_1v2.n604 vss_1v2 0.04264f ; **FLOATING
C1320 vdd_1v2.t435 vss_1v2 0.02871f ; **FLOATING
C1321 vdd_1v2.t439 vss_1v2 0.02618f ; **FLOATING
C1322 vdd_1v2.n605 vss_1v2 0.03653f ; **FLOATING
C1323 vdd_1v2.t340 vss_1v2 0.02618f ; **FLOATING
C1324 vdd_1v2.n606 vss_1v2 0.0182f ; **FLOATING
C1325 vdd_1v2.n607 vss_1v2 0.01334f ; **FLOATING
C1326 vdd_1v2.n608 vss_1v2 0.03602f ; **FLOATING
C1327 vdd_1v2.t443 vss_1v2 0.03132f ; **FLOATING
C1328 vdd_1v2.t447 vss_1v2 0.02867f ; **FLOATING
C1329 vdd_1v2.n609 vss_1v2 0.03903f ; **FLOATING
C1330 vdd_1v2.t449 vss_1v2 0.02729f ; **FLOATING
C1331 vdd_1v2.n610 vss_1v2 0.03399f ; **FLOATING
C1332 vdd_1v2.n611 vss_1v2 0.01922f ; **FLOATING
C1333 vdd_1v2.n612 vss_1v2 0.02509f ; **FLOATING
C1334 vdd_1v2.t441 vss_1v2 0.03113f ; **FLOATING
C1335 vdd_1v2.n613 vss_1v2 0.03961f ; **FLOATING
C1336 vdd_1v2.n618 vss_1v2 0.01329f ; **FLOATING
C1337 vdd_1v2.t451 vss_1v2 0.0165f ; **FLOATING
C1338 vdd_1v2.n624 vss_1v2 0.01759f ; **FLOATING
C1339 vdd_1v2.t450 vss_1v2 0.01172f ; **FLOATING
C1340 vdd_1v2.n629 vss_1v2 0.02052f ; **FLOATING
C1341 vdd_1v2.t378 vss_1v2 0.0131f ; **FLOATING
C1342 vdd_1v2.t393 vss_1v2 0.01787f ; **FLOATING
C1343 vdd_1v2.n635 vss_1v2 0.01759f ; **FLOATING
C1344 vdd_1v2.n636 vss_1v2 0.01285f ; **FLOATING
C1345 vdd_1v2.n637 vss_1v2 0.01521f ; **FLOATING
C1346 vdd_1v2.t391 vss_1v2 0.02311f ; **FLOATING
C1347 vdd_1v2.t396 vss_1v2 0.02302f ; **FLOATING
C1348 vdd_1v2.t398 vss_1v2 0.01196f ; **FLOATING
C1349 enable.n0 vss_1v2 0.9224f ; **FLOATING
C1350 enable.t11 vss_1v2 0.11363f ; **FLOATING
C1351 enable.t10 vss_1v2 0.10413f ; **FLOATING
C1352 enable.n1 vss_1v2 0.54847f ; **FLOATING
C1353 enable.t6 vss_1v2 0.09154f ; **FLOATING
C1354 enable.t7 vss_1v2 0.08925f ; **FLOATING
C1355 enable.n2 vss_1v2 1.02192f ; **FLOATING
C1356 enable.t9 vss_1v2 0.08996f ; **FLOATING
C1357 enable.t8 vss_1v2 0.08996f ; **FLOATING
C1358 enable.n3 vss_1v2 0.66447f ; **FLOATING
C1359 enable.t0 vss_1v2 0.90661f ; **FLOATING
C1360 enable.t1 vss_1v2 0.57979f ; **FLOATING
C1361 enable.n4 vss_1v2 2.2383f ; **FLOATING
C1362 enable.n5 vss_1v2 1.3891f ; **FLOATING
C1363 enable.t3 vss_1v2 0.58254f ; **FLOATING
C1364 enable.n6 vss_1v2 0.91633f ; **FLOATING
C1365 enable.t4 vss_1v2 0.39955f ; **FLOATING
C1366 enable.t5 vss_1v2 0.32933f ; **FLOATING
C1367 enable.n7 vss_1v2 0.6117f ; **FLOATING
C1368 enable.n8 vss_1v2 0.79161f ; **FLOATING
C1369 enable.t2 vss_1v2 0.51528f ; **FLOATING
C1370 enable.n9 vss_1v2 17.264f ; **FLOATING
.ends
