* NGSPICE file created from sg13cmos5l_yacinesot_ip__diff_opamp_cmfb.ext - technology: ihp-sg13cmos5l

.subckt sg13cmos5l_yacinesot_ip__diff_opamp_cmfb s5_an[1] analog_bus0 analog_bus1
+ ibias0 enable s5_an[2] s5_an[0] vdd_1v2 vss_1v2
X0 vss_1v2 vss_1v2 vss_1v2 vss_1v2 sg13_lv_nmos mm_ok=1 ad=0.133p pd=1.08u as=1.79784n ps=2.93092m w=0.7u l=0.5u
X1 vss_1v2 vss_1v2 vss_1v2 vss_1v2 sg13_lv_nmos mm_ok=1 ad=95f pd=0.88u as=0 ps=0 w=0.5u l=0.5u
X2 ota_cmfb_top_0.ota_cmfb_core_push_pull_output_stage_0/dynamic_pcell_4_0.DRN_NET_HI ota_cmfb_top_0.dynamic_pcell_5_0.F_DRN vdd_1v2 vdd_1v2 sg13_lv_pmos mm_ok=1 ad=0.475p pd=2.88u as=0.85p ps=5.68u w=2.5u l=3u
X3 ota_cmfb_top_0.ota_cmfb_core_push_pull_output_stage_1/dynamic_pcell_4_0.SRC_NET_IJ_GATE_DI ota_cmfb_top_0.ota_cmfb_core_push_pull_output_stage_1/dynamic_pcell_4_0.SRC_NET_IJ_GATE_DI ota_cmfb_top_0.ota_cmfb_core_push_pull_output_stage_1/dynamic_pcell_4_0.DRN_NET_HI vdd_1v2 sg13_lv_pmos mm_ok=1 ad=0.475p pd=2.88u as=0.475p ps=2.88u w=2.5u l=3u
X4 vss_1v2 vss_1v2 vss_1v2 vss_1v2 sg13_lv_nmos mm_ok=1 ad=0.238p pd=2.08u as=0 ps=0 w=0.7u l=0.5u
X5 vdd_1v2 vdd_1v2 vdd_1v2 vdd_1v2 sg13_lv_pmos mm_ok=1 ad=0.85p pd=5.68u as=1.87833n ps=3.16758m w=2.5u l=0.5u
X6 vdd_1v2 enable ota_cmfb_top_0.EN_INV_0/sg13cmos5l_inv_4_0.Y vdd_1v2 sg13_lv_pmos mm_ok=1 ad=0.3808p pd=2.92u as=0.2128p ps=1.5u w=1.12u l=0.13u
X7 ota_cmfb_top_0.ota_cmfb_core_push_pull_output_stage_0/dynamic_pcell_4_0.B_DRN ota_cmfb_top_0.ota_cmfb_core_push_pull_output_stage_0/dynamic_pcell_4_0.B_DRN ota_cmfb_top_0.ota_cmfb_core_push_pull_output_stage_0/dynamic_pcell_4_0.DRN_NET_OP_GATE_MP vss_1v2 sg13_lv_nmos mm_ok=1 ad=0.133p pd=1.08u as=0.133p ps=1.08u w=0.7u l=3u
X8 ota_cmfb_top_0.ota_cmfb_core_push_pull_output_stage_0/dynamic_pcell_4_0.DRN_NET_MENX ota_cmfb_top_0.ota_cmfb_core_push_pull_output_stage_0/dynamic_pcell_4_0.B_DRN ota_cmfb_top_0.dynamic_pcell_5_0.DRN_NET_BD vss_1v2 sg13_lv_nmos mm_ok=1 ad=0.133p pd=1.08u as=0.133p ps=1.08u w=0.7u l=3u
X9 vss_1v2 ibias0 ota_cmfb_top_0.dynamic_pcell_5_0.DRN_NET_CA vss_1v2 sg13_lv_nmos mm_ok=1 ad=62.5f pd=0.74u as=62.5f ps=0.74u w=0.25u l=10u
X10 vss_1v2 vss_1v2 vss_1v2 vss_1v2 sg13_lv_nmos mm_ok=1 ad=0.238p pd=2.08u as=0 ps=0 w=0.7u l=0.5u
X11 a_50660_27418# a_50924_27132# vss_1v2 rhigh l=1u w=0.5u
X12 ota_cmfb_top_0.dynamic_pcell_5_0.DRN_NET_CA ota_cmfb_top_0.ota_cmfb_core_push_pull_output_stage_1/dynamic_pcell_4_0.SRC_NET_IJ_GATE_DI ota_cmfb_top_0.ota_cmfb_core_push_pull_output_stage_1/dynamic_pcell_4_0.DRN_NET_CD vdd_1v2 sg13_lv_pmos mm_ok=1 ad=0.475p pd=2.88u as=0.85p ps=5.68u w=2.5u l=3u
X13 vdd_1v2 vdd_1v2 vdd_1v2 vdd_1v2 sg13_lv_pmos mm_ok=1 ad=0.425p pd=3.18u as=0 ps=0 w=1.25u l=0.5u
X14 ota_cmfb_top_0.dynamic_pcell_5_0.DRN_NET_BD ota_cmfb_top_0.ota_cmfb_core_push_pull_output_stage_0/dynamic_pcell_4_0.SRC_NET_IJ_GATE_DI ota_cmfb_top_0.ota_cmfb_core_push_pull_output_stage_0/dynamic_pcell_4_0.DRN_NET_CD vdd_1v2 sg13_lv_pmos mm_ok=1 ad=0.475p pd=2.88u as=0.85p ps=5.68u w=2.5u l=3u
X15 vss_1v2 ibias0 ota_cmfb_top_0.dynamic_pcell_5_0.DRN_NET_BD vss_1v2 sg13_lv_nmos mm_ok=1 ad=62.5f pd=0.74u as=62.5f ps=0.74u w=0.25u l=10u
X16 a_50924_27979# s5_an[2] vss_1v2 rhigh l=1u w=0.5u
X17 a_58402_34440# a_58402_33917# vss_1v2 rhigh l=1u w=0.5u
X18 vss_1v2 vss_1v2 ota_cmfb_top_0.ota_cmfb_core_push_pull_output_stage_1/dynamic_pcell_4_0.DRN_NET_MENX vss_1v2 sg13_lv_nmos mm_ok=1 ad=0.133p pd=1.08u as=0.133p ps=1.08u w=0.7u l=3u
X19 vdd_1v2 vdd_1v2 ota_cmfb_top_0.ota_cmfb_core_push_pull_output_stage_0/dynamic_pcell_4_0.DRN_NET_CD vdd_1v2 sg13_lv_pmos mm_ok=1 ad=0.475p pd=2.88u as=0.475p ps=2.88u w=2.5u l=0.5u
X20 ota_cmfb_top_0.ota_cmfb_core_push_pull_output_stage_0/dynamic_pcell_4_0.DRN_NET_OP_GATE_MP ota_cmfb_top_0.ota_cmfb_core_push_pull_output_stage_0/dynamic_pcell_4_0.DRN_NET_OP_GATE_MP ota_cmfb_top_0.ota_cmfb_core_push_pull_output_stage_0/dynamic_pcell_4_0.SRC_NET_QP_GATE_KLQ vss_1v2 sg13_lv_nmos mm_ok=1 ad=0.133p pd=1.08u as=0.133p ps=1.08u w=0.7u l=3u
X21 ota_cmfb_top_0.ota_cmfb_core_push_pull_output_stage_1/dynamic_pcell_4_0.DRN_NET_HI ota_cmfb_top_0.ota_cmfb_core_push_pull_output_stage_1/dynamic_pcell_4_0.SRC_NET_IJ_GATE_DI ota_cmfb_top_0.ota_cmfb_core_push_pull_output_stage_1/dynamic_pcell_4_0.SRC_NET_IJ_GATE_DI vdd_1v2 sg13_lv_pmos mm_ok=1 ad=0.475p pd=2.88u as=0.475p ps=2.88u w=2.5u l=3u
X22 vdd_1v2 ota_cmfb_top_0.dynamic_pcell_5_0.H_DRN ota_cmfb_top_0.dynamic_pcell_5_0.SRC_NET_KL vdd_1v2 sg13_lv_pmos mm_ok=1 ad=0.2375p pd=1.63u as=0.2375p ps=1.63u w=1.25u l=5u
X23 ota_cmfb_top_0.ota_cmfb_core_push_pull_output_stage_0/dynamic_pcell_4_0.DRN_NET_HI ota_cmfb_top_0.ota_cmfb_core_push_pull_output_stage_0/dynamic_pcell_4_0.SRC_NET_IJ_GATE_DI ota_cmfb_top_0.ota_cmfb_core_push_pull_output_stage_0/dynamic_pcell_4_0.SRC_NET_IJ_GATE_DI vdd_1v2 sg13_lv_pmos mm_ok=1 ad=0.475p pd=2.88u as=0.475p ps=2.88u w=2.5u l=3u
X24 vss_1v2 vss_1v2 vss_1v2 vss_1v2 sg13_lv_nmos mm_ok=1 ad=95f pd=0.88u as=0 ps=0 w=0.5u l=0.5u
X25 vdd_1v2 vdd_1v2 vdd_1v2 vdd_1v2 sg13_lv_pmos mm_ok=1 ad=0.2375p pd=1.63u as=0 ps=0 w=1.25u l=0.5u
X26 ota_cmfb_top_0.ota_cmfb_core_push_pull_output_stage_1/dynamic_pcell_4_0.DRN_NET_OP_GATE_MP ota_cmfb_top_0.ota_cmfb_core_push_pull_output_stage_1/dynamic_pcell_4_0.DRN_NET_OP_GATE_MP ota_cmfb_top_0.ota_cmfb_core_push_pull_output_stage_1/dynamic_pcell_4_0.SRC_NET_QP_GATE_KLQ vss_1v2 sg13_lv_nmos mm_ok=1 ad=0.133p pd=1.08u as=0.133p ps=1.08u w=0.7u l=3u
X27 vss_1v2 vss_1v2 ota_cmfb_top_0.dynamic_pcell_5_0.G_DRN vss_1v2 sg13_lv_nmos mm_ok=1 ad=62.5f pd=0.74u as=62.5f ps=0.74u w=0.25u l=0.5u
X28 vdd_1v2 ota_cmfb_top_0.dynamic_pcell_5_0.DRN_NET_BD s5_an[2] vdd_1v2 sg13_lv_pmos mm_ok=1 ad=95f pd=0.88u as=95f ps=0.88u w=0.5u l=0.5u
X29 ota_cmfb_top_0.dynamic_pcell_5_0.G_DRN ota_cmfb_top_0.dynamic_pcell_5_0.G_DRN vdd_1v2 vdd_1v2 sg13_lv_pmos mm_ok=1 ad=0.475p pd=2.88u as=0.475p ps=2.88u w=2.5u l=3u
X30 vss_1v2 vss_1v2 vss_1v2 vss_1v2 sg13_lv_nmos mm_ok=1 ad=95f pd=0.88u as=0 ps=0 w=0.5u l=0.5u
X31 vss_1v2 vss_1v2 vss_1v2 vss_1v2 sg13_lv_nmos mm_ok=1 ad=95f pd=0.88u as=0 ps=0 w=0.5u l=0.5u
X32 ota_cmfb_top_0.dynamic_pcell_5_0.F_DRN ota_cmfb_top_0.dynamic_pcell_5_0.F_DRN vdd_1v2 vdd_1v2 sg13_lv_pmos mm_ok=1 ad=0.475p pd=2.88u as=0.475p ps=2.88u w=2.5u l=3u
X33 a_49868_27979# a_50132_27693# vss_1v2 rhigh l=1u w=0.5u
X34 vss_1v2 vss_1v2 ota_cmfb_top_0.ota_cmfb_core_push_pull_output_stage_0/dynamic_pcell_4_0.DRN_NET_MENX vss_1v2 sg13_lv_nmos mm_ok=1 ad=0.133p pd=1.08u as=0.133p ps=1.08u w=0.7u l=3u
X35 vss_1v2 ota_cmfb_top_0.ota_cmfb_core_push_pull_output_stage_0/dynamic_pcell_4_0.SRC_NET_QP_GATE_KLQ ota_cmfb_top_0.ota_cmfb_core_push_pull_output_stage_0/dynamic_pcell_4_0.SRC_NET_QP_GATE_KLQ vss_1v2 sg13_lv_nmos mm_ok=1 ad=0.133p pd=1.08u as=0.133p ps=1.08u w=0.7u l=3u
X36 ota_cmfb_top_0.ota_cmfb_core_push_pull_output_stage_1/dynamic_pcell_4_0.B_DRN ota_cmfb_top_0.dynamic_pcell_5_0.G_DRN vdd_1v2 vdd_1v2 sg13_lv_pmos mm_ok=1 ad=0.475p pd=2.88u as=0.475p ps=2.88u w=2.5u l=3u
X37 ota_cmfb_top_0.dynamic_pcell_5_0.DRN_NET_IK_GATE_IJ ota_cmfb_top_0.dynamic_pcell_5_0.DRN_NET_IK_GATE_IJ vss_1v2 vss_1v2 sg13_lv_nmos mm_ok=1 ad=62.5f pd=0.74u as=62.5f ps=0.74u w=0.25u l=10u
X38 vss_1v2 vss_1v2 vss_1v2 vss_1v2 sg13_lv_nmos mm_ok=1 ad=95f pd=0.88u as=0 ps=0 w=0.5u l=0.5u
X39 vdd_1v2 enable ota_cmfb_top_0.EN_INV_1/sg13cmos5l_inv_4_0.Y vdd_1v2 sg13_lv_pmos mm_ok=1 ad=0.3808p pd=2.92u as=0.2128p ps=1.5u w=1.12u l=0.13u
X40 vss_1v2 vss_1v2 vss_1v2 vss_1v2 sg13_lv_nmos mm_ok=1 ad=0.238p pd=2.08u as=0 ps=0 w=0.7u l=0.5u
X41 ota_cmfb_top_0.ota_cmfb_core_push_pull_output_stage_1/dynamic_pcell_4_0.DRN_NET_MENX ota_cmfb_top_0.ota_cmfb_core_push_pull_output_stage_1/dynamic_pcell_4_0.DRN_NET_OP_GATE_MP ota_cmfb_top_0.ota_cmfb_core_push_pull_output_stage_1/dynamic_pcell_4_0.SRC_NET_ML vss_1v2 sg13_lv_nmos mm_ok=1 ad=0.133p pd=1.08u as=0.133p ps=1.08u w=0.7u l=3u
X42 vdd_1v2 vdd_1v2 vdd_1v2 vdd_1v2 sg13_lv_pmos mm_ok=1 ad=0.475p pd=2.88u as=0 ps=0 w=2.5u l=0.5u
X43 vss_1v2 ibias0 ota_cmfb_top_0.dynamic_pcell_5_0.DRN_NET_CA vss_1v2 sg13_lv_nmos mm_ok=1 ad=62.5f pd=0.74u as=62.5f ps=0.74u w=0.25u l=10u
X44 vdd_1v2 vdd_1v2 ota_cmfb_top_0.dynamic_pcell_5_0.DRN_NET_BD vdd_1v2 sg13_lv_pmos mm_ok=1 ad=0.475p pd=2.88u as=0.475p ps=2.88u w=2.5u l=0.5u
X45 s5_an[1] a_50924_27132# vss_1v2 rhigh l=1u w=0.5u
X46 ota_cmfb_top_0.ota_cmfb_core_push_pull_output_stage_1/dynamic_pcell_4_0.DRN_NET_HI ota_cmfb_top_0.ota_cmfb_core_push_pull_output_stage_1/dynamic_pcell_4_0.SRC_NET_IJ_GATE_DI ota_cmfb_top_0.ota_cmfb_core_push_pull_output_stage_1/dynamic_pcell_4_0.SRC_NET_IJ_GATE_DI vdd_1v2 sg13_lv_pmos mm_ok=1 ad=0.475p pd=2.88u as=0.85p ps=5.68u w=2.5u l=3u
X47 ota_cmfb_top_0.ota_cmfb_core_push_pull_output_stage_1/dynamic_pcell_4_0.SRC_NET_QP_GATE_KLQ ota_cmfb_top_0.ota_cmfb_core_push_pull_output_stage_1/dynamic_pcell_4_0.SRC_NET_QP_GATE_KLQ vss_1v2 vss_1v2 sg13_lv_nmos mm_ok=1 ad=0.133p pd=1.08u as=0.133p ps=1.08u w=0.7u l=3u
X48 ota_cmfb_top_0.ota_cmfb_core_push_pull_output_stage_0/dynamic_pcell_4_0.DRN_NET_OP_GATE_MP vss_1v2 vss_1v2 vss_1v2 sg13_lv_nmos mm_ok=1 ad=0.133p pd=1.08u as=0.133p ps=1.08u w=0.7u l=0.5u
X49 ota_cmfb_top_0.ota_cmfb_core_push_pull_output_stage_0/dynamic_pcell_4_0.DRN_NET_HI ota_cmfb_top_0.ota_cmfb_core_push_pull_output_stage_0/dynamic_pcell_4_0.SRC_NET_IJ_GATE_DI ota_cmfb_top_0.ota_cmfb_core_push_pull_output_stage_0/dynamic_pcell_4_0.SRC_NET_IJ_GATE_DI vdd_1v2 sg13_lv_pmos mm_ok=1 ad=0.475p pd=2.88u as=0.85p ps=5.68u w=2.5u l=3u
X50 vss_1v2 vss_1v2 vss_1v2 vss_1v2 sg13_lv_nmos mm_ok=1 ad=62.5f pd=0.74u as=0 ps=0 w=0.25u l=0.5u
X51 vdd_1v2 vdd_1v2 vdd_1v2 vdd_1v2 sg13_lv_pmos mm_ok=1 ad=95f pd=0.88u as=0 ps=0 w=0.5u l=0.5u
X52 vdd_1v2 vdd_1v2 ota_cmfb_top_0.ota_cmfb_core_push_pull_output_stage_0/dynamic_pcell_4_0.SRC_NET_IJ_GATE_DI vdd_1v2 sg13_lv_pmos mm_ok=1 ad=0.475p pd=2.88u as=0.475p ps=2.88u w=2.5u l=0.5u
X53 vdd_1v2 ota_cmfb_top_0.dynamic_pcell_5_0.G_DRN ota_cmfb_top_0.ota_cmfb_core_push_pull_output_stage_1/dynamic_pcell_4_0.B_DRN vdd_1v2 sg13_lv_pmos mm_ok=1 ad=0.475p pd=2.88u as=0.475p ps=2.88u w=2.5u l=3u
X54 ota_cmfb_top_0.dynamic_pcell_5_0.DRN_NET_CA analog_bus0 ota_cmfb_top_0.dynamic_pcell_5_0.SRC_NET_AB vdd_1v2 sg13_lv_pmos mm_ok=1 ad=0.475p pd=2.88u as=0.475p ps=2.88u w=2.5u l=2u
X55 ota_cmfb_top_0.dynamic_pcell_5_0.G_DRN vss_1v2 vss_1v2 vss_1v2 sg13_lv_nmos mm_ok=1 ad=62.5f pd=0.74u as=62.5f ps=0.74u w=0.25u l=0.5u
X56 ota_cmfb_top_0.dynamic_pcell_5_0.DRN_NET_CA ota_cmfb_top_0.ota_cmfb_core_push_pull_output_stage_1/dynamic_pcell_4_0.DRN_NET_J_GATE_EJ ota_cmfb_top_0.ota_cmfb_core_push_pull_output_stage_1/dynamic_pcell_4_0.DRN_NET_MENX vdd_1v2 sg13_lv_pmos mm_ok=1 ad=0.85p pd=5.68u as=0.475p ps=2.88u w=2.5u l=3u
X57 vdd_1v2 vdd_1v2 vdd_1v2 vdd_1v2 sg13_lv_pmos mm_ok=1 ad=0.475p pd=2.88u as=0 ps=0 w=2.5u l=0.5u
X58 vdd_1v2 ota_cmfb_top_0.dynamic_pcell_5_0.G_DRN ota_cmfb_top_0.dynamic_pcell_5_0.G_DRN vdd_1v2 sg13_lv_pmos mm_ok=1 ad=0.475p pd=2.88u as=0.85p ps=5.68u w=2.5u l=3u
X59 ota_cmfb_top_0.ota_cmfb_core_push_pull_output_stage_1/dynamic_pcell_4_0.DRN_NET_MENX ota_cmfb_top_0.ota_cmfb_core_push_pull_output_stage_1/dynamic_pcell_4_0.B_DRN ota_cmfb_top_0.dynamic_pcell_5_0.DRN_NET_CA vss_1v2 sg13_lv_nmos mm_ok=1 ad=0.133p pd=1.08u as=0.133p ps=1.08u w=0.7u l=3u
X60 vdd_1v2 vdd_1v2 vdd_1v2 vdd_1v2 sg13_lv_pmos mm_ok=1 ad=0.475p pd=2.88u as=0 ps=0 w=2.5u l=0.5u
X61 vdd_1v2 ota_cmfb_top_0.dynamic_pcell_5_0.G_DRN ota_cmfb_top_0.dynamic_pcell_5_0.G_DRN vdd_1v2 sg13_lv_pmos mm_ok=1 ad=0.475p pd=2.88u as=0.475p ps=2.88u w=2.5u l=3u
X62 enable vdd_1v2 dpantenna l=1.34u w=1.05u
X63 vdd_1v2 vdd_1v2 vdd_1v2 vdd_1v2 sg13_lv_pmos mm_ok=1 ad=0.17p pd=1.68u as=0 ps=0 w=0.5u l=0.5u
X64 a_50132_27418# a_49868_27132# vss_1v2 rhigh l=1u w=0.5u
X65 ota_cmfb_top_0.ota_cmfb_core_push_pull_output_stage_0/dynamic_pcell_4_0.SRC_NET_QP_GATE_KLQ ota_cmfb_top_0.ota_cmfb_core_push_pull_output_stage_0/dynamic_pcell_4_0.SRC_NET_QP_GATE_KLQ vss_1v2 vss_1v2 sg13_lv_nmos mm_ok=1 ad=0.133p pd=1.08u as=0.133p ps=1.08u w=0.7u l=3u
X66 vdd_1v2 ota_cmfb_top_0.dynamic_pcell_5_0.DRN_NET_BD s5_an[2] vdd_1v2 sg13_lv_pmos mm_ok=1 ad=95f pd=0.88u as=95f ps=0.88u w=0.5u l=0.5u
X67 vdd_1v2 ota_cmfb_top_0.dynamic_pcell_5_0.G_DRN ota_cmfb_top_0.dynamic_pcell_5_0.G_DRN vdd_1v2 sg13_lv_pmos mm_ok=1 ad=0.85p pd=5.68u as=0.475p ps=2.88u w=2.5u l=3u
X68 vss_1v2 vss_1v2 vss_1v2 vss_1v2 sg13_lv_nmos mm_ok=1 ad=62.5f pd=0.74u as=0 ps=0 w=0.25u l=0.5u
X69 ota_cmfb_top_0.ota_cmfb_core_push_pull_output_stage_1/dynamic_pcell_4_0.DRN_NET_HI ota_cmfb_top_0.dynamic_pcell_5_0.G_DRN vdd_1v2 vdd_1v2 sg13_lv_pmos mm_ok=1 ad=0.475p pd=2.88u as=0.475p ps=2.88u w=2.5u l=3u
X70 vdd_1v2 vdd_1v2 vdd_1v2 vdd_1v2 sg13_lv_pmos mm_ok=1 ad=0.2375p pd=1.63u as=0 ps=0 w=1.25u l=0.5u
X71 vdd_1v2 vdd_1v2 ota_cmfb_top_0.dynamic_pcell_5_0.DRN_NET_JL vdd_1v2 sg13_lv_pmos mm_ok=1 ad=0.475p pd=2.88u as=0.475p ps=2.88u w=2.5u l=0.5u
X72 vdd_1v2 vdd_1v2 vdd_1v2 vdd_1v2 sg13_lv_pmos mm_ok=1 ad=0.85p pd=5.68u as=0 ps=0 w=2.5u l=0.5u
X73 ota_cmfb_top_0.ota_cmfb_core_push_pull_output_stage_1/dynamic_pcell_4_0.SRC_NET_QP_GATE_KLQ ota_cmfb_top_0.ota_cmfb_core_push_pull_output_stage_1/dynamic_pcell_4_0.SRC_NET_QP_GATE_KLQ vss_1v2 vss_1v2 sg13_lv_nmos mm_ok=1 ad=0.133p pd=1.08u as=0.133p ps=1.08u w=0.7u l=3u
X74 vss_1v2 ibias0 ota_cmfb_top_0.dynamic_pcell_5_0.DRN_NET_BD vss_1v2 sg13_lv_nmos mm_ok=1 ad=62.5f pd=0.74u as=62.5f ps=0.74u w=0.25u l=10u
X75 ota_cmfb_top_0.ota_cmfb_core_push_pull_output_stage_1/dynamic_pcell_4_0.SRC_NET_ML ota_cmfb_top_0.ota_cmfb_core_push_pull_output_stage_1/dynamic_pcell_4_0.SRC_NET_QP_GATE_KLQ vss_1v2 vss_1v2 sg13_lv_nmos mm_ok=1 ad=0.133p pd=1.08u as=0.133p ps=1.08u w=0.7u l=3u
X76 ota_cmfb_top_0.ota_cmfb_core_push_pull_output_stage_0/dynamic_pcell_4_0.SRC_NET_QP_GATE_KLQ ota_cmfb_top_0.ota_cmfb_core_push_pull_output_stage_0/dynamic_pcell_4_0.SRC_NET_QP_GATE_KLQ vss_1v2 vss_1v2 sg13_lv_nmos mm_ok=1 ad=0.133p pd=1.08u as=0.133p ps=1.08u w=0.7u l=3u
X77 ota_cmfb_top_0.ota_cmfb_core_push_pull_output_stage_0/dynamic_pcell_4_0.DRN_NET_MENX vss_1v2 vss_1v2 vss_1v2 sg13_lv_nmos mm_ok=1 ad=0.133p pd=1.08u as=0.133p ps=1.08u w=0.7u l=0.5u
X78 vdd_1v2 vdd_1v2 vdd_1v2 vdd_1v2 sg13_lv_pmos mm_ok=1 ad=0.475p pd=2.88u as=0 ps=0 w=2.5u l=0.5u
X79 vdd_1v2 vdd_1v2 vdd_1v2 vdd_1v2 sg13_lv_pmos mm_ok=1 ad=0.85p pd=5.68u as=0 ps=0 w=2.5u l=0.5u
X80 vss_1v2 vss_1v2 ota_cmfb_top_0.ota_cmfb_core_push_pull_output_stage_0/dynamic_pcell_4_0.DRN_NET_OP_GATE_MP vss_1v2 sg13_lv_nmos mm_ok=1 ad=0.133p pd=1.08u as=0.133p ps=1.08u w=0.7u l=0.5u
X81 vdd_1v2 ota_cmfb_top_0.dynamic_pcell_5_0.DRN_NET_CA s5_an[1] vdd_1v2 sg13_lv_pmos mm_ok=1 ad=95f pd=0.88u as=95f ps=0.88u w=0.5u l=0.5u
X82 vss_1v2 vss_1v2 vss_1v2 vss_1v2 sg13_lv_nmos mm_ok=1 ad=0.133p pd=1.08u as=0 ps=0 w=0.7u l=0.5u
X83 vss_1v2 vss_1v2 vss_1v2 vss_1v2 sg13_lv_nmos mm_ok=1 ad=95f pd=0.88u as=0 ps=0 w=0.5u l=0.5u
X84 ibias0 vss_1v2 vss_1v2 vss_1v2 sg13_lv_nmos mm_ok=1 ad=62.5f pd=0.74u as=62.5f ps=0.74u w=0.25u l=0.5u
X85 vdd_1v2 vdd_1v2 vdd_1v2 vdd_1v2 sg13_lv_pmos mm_ok=1 ad=95f pd=0.88u as=0 ps=0 w=0.5u l=0.5u
X86 vss_1v2 ota_cmfb_top_0.ota_cmfb_core_push_pull_output_stage_1/dynamic_pcell_4_0.SRC_NET_QP_GATE_KLQ ota_cmfb_top_0.ota_cmfb_core_push_pull_output_stage_1/dynamic_pcell_4_0.SRC_NET_QP_GATE_KLQ vss_1v2 sg13_lv_nmos mm_ok=1 ad=0.133p pd=1.08u as=0.133p ps=1.08u w=0.7u l=3u
X87 vss_1v2 vss_1v2 vss_1v2 vss_1v2 sg13_lv_nmos mm_ok=1 ad=0.17p pd=1.68u as=0 ps=0 w=0.5u l=0.5u
X88 vss_1v2 vss_1v2 vss_1v2 vss_1v2 sg13_lv_nmos mm_ok=1 ad=95f pd=0.88u as=0 ps=0 w=0.5u l=0.5u
X89 vss_1v2 vss_1v2 vss_1v2 vss_1v2 sg13_lv_nmos mm_ok=1 ad=62.5f pd=0.74u as=0 ps=0 w=0.25u l=0.5u
X90 ota_cmfb_top_0.ota_cmfb_core_push_pull_output_stage_1/dynamic_pcell_4_0.DRN_NET_J_GATE_EJ ota_cmfb_top_0.ota_cmfb_core_push_pull_output_stage_1/dynamic_pcell_4_0.DRN_NET_J_GATE_EJ ota_cmfb_top_0.ota_cmfb_core_push_pull_output_stage_1/dynamic_pcell_4_0.SRC_NET_IJ_GATE_DI vdd_1v2 sg13_lv_pmos mm_ok=1 ad=0.475p pd=2.88u as=0.475p ps=2.88u w=2.5u l=3u
X91 vdd_1v2 vdd_1v2 vdd_1v2 vdd_1v2 sg13_lv_pmos mm_ok=1 ad=95f pd=0.88u as=0 ps=0 w=0.5u l=0.5u
X92 vss_1v2 vss_1v2 vss_1v2 vss_1v2 sg13_lv_nmos mm_ok=1 ad=62.5f pd=0.74u as=0 ps=0 w=0.25u l=0.5u
X93 vss_1v2 ota_cmfb_top_0.ota_cmfb_core_push_pull_output_stage_1/dynamic_pcell_4_0.SRC_NET_QP_GATE_KLQ ota_cmfb_top_0.ota_cmfb_core_push_pull_output_stage_1/dynamic_pcell_4_0.SRC_NET_QP_GATE_KLQ vss_1v2 sg13_lv_nmos mm_ok=1 ad=0.133p pd=1.08u as=0.133p ps=1.08u w=0.7u l=3u
X94 ota_cmfb_top_0.dynamic_pcell_5_0.DRN_NET_CA ota_cmfb_top_0.ota_cmfb_core_push_pull_output_stage_1/dynamic_pcell_4_0.B_DRN ota_cmfb_top_0.ota_cmfb_core_push_pull_output_stage_1/dynamic_pcell_4_0.DRN_NET_MENX vss_1v2 sg13_lv_nmos mm_ok=1 ad=0.133p pd=1.08u as=0.133p ps=1.08u w=0.7u l=3u
X95 vdd_1v2 vdd_1v2 vdd_1v2 vdd_1v2 sg13_lv_pmos mm_ok=1 ad=0.17p pd=1.68u as=0 ps=0 w=0.5u l=0.5u
X96 vss_1v2 ibias0 ota_cmfb_top_0.dynamic_pcell_5_0.DRN_NET_BD vss_1v2 sg13_lv_nmos mm_ok=1 ad=62.5f pd=0.74u as=62.5f ps=0.74u w=0.25u l=10u
X97 vdd_1v2 vdd_1v2 vdd_1v2 vdd_1v2 sg13_lv_pmos mm_ok=1 ad=95f pd=0.88u as=0 ps=0 w=0.5u l=0.5u
X98 ota_cmfb_top_0.dynamic_pcell_5_0.DRN_NET_BD ota_cmfb_top_0.ota_cmfb_core_push_pull_output_stage_0/dynamic_pcell_4_0.B_DRN ota_cmfb_top_0.ota_cmfb_core_push_pull_output_stage_0/dynamic_pcell_4_0.DRN_NET_MENX vss_1v2 sg13_lv_nmos mm_ok=1 ad=0.133p pd=1.08u as=0.133p ps=1.08u w=0.7u l=3u
X99 ota_cmfb_top_0.ota_cmfb_core_push_pull_output_stage_0/dynamic_pcell_4_0.DRN_NET_OP_GATE_MP vss_1v2 vss_1v2 vss_1v2 sg13_lv_nmos mm_ok=1 ad=0.133p pd=1.08u as=0.133p ps=1.08u w=0.7u l=0.5u
X100 vdd_1v2 vdd_1v2 vdd_1v2 vdd_1v2 sg13_lv_pmos mm_ok=1 ad=0.17p pd=1.68u as=0 ps=0 w=0.5u l=0.5u
X101 vss_1v2 a_45783_27500# dantenna l=0.78u w=0.78u
X102 ota_cmfb_top_0.dynamic_pcell_5_0.SRC_NET_KL ota_cmfb_top_0.dynamic_pcell_5_0.H_DRN vdd_1v2 vdd_1v2 sg13_lv_pmos mm_ok=1 ad=0.2375p pd=1.63u as=0.2375p ps=1.63u w=1.25u l=5u
X103 vss_1v2 vss_1v2 vss_1v2 vss_1v2 sg13_lv_nmos mm_ok=1 ad=95f pd=0.88u as=0 ps=0 w=0.5u l=0.5u
X104 vss_1v2 ota_cmfb_top_0.ota_cmfb_core_push_pull_output_stage_0/dynamic_pcell_4_0.SRC_NET_QP_GATE_KLQ ota_cmfb_top_0.ota_cmfb_core_push_pull_output_stage_0/dynamic_pcell_4_0.SRC_NET_ML vss_1v2 sg13_lv_nmos mm_ok=1 ad=0.133p pd=1.08u as=0.133p ps=1.08u w=0.7u l=3u
X105 vss_1v2 vss_1v2 ota_cmfb_top_0.ota_cmfb_core_push_pull_output_stage_0/dynamic_pcell_4_0.DRN_NET_MENX vss_1v2 sg13_lv_nmos mm_ok=1 ad=0.133p pd=1.08u as=0.133p ps=1.08u w=0.7u l=0.5u
X106 vdd_1v2 vdd_1v2 ota_cmfb_top_0.dynamic_pcell_5_0.H_DRN vdd_1v2 sg13_lv_pmos mm_ok=1 ad=0.2375p pd=1.63u as=0.2375p ps=1.63u w=1.25u l=0.5u
X107 vdd_1v2 ota_cmfb_top_0.dynamic_pcell_5_0.H_DRN ota_cmfb_top_0.dynamic_pcell_5_0.SRC_NET_KL vdd_1v2 sg13_lv_pmos mm_ok=1 ad=0.2375p pd=1.63u as=0.2375p ps=1.63u w=1.25u l=5u
X108 ota_cmfb_top_0.ota_cmfb_core_push_pull_output_stage_1/dynamic_pcell_4_0.DRN_NET_CD ota_cmfb_top_0.dynamic_pcell_5_0.G_DRN vdd_1v2 vdd_1v2 sg13_lv_pmos mm_ok=1 ad=0.475p pd=2.88u as=0.475p ps=2.88u w=2.5u l=3u
X109 ota_cmfb_top_0.dynamic_pcell_5_0.H_DRN vss_1v2 vss_1v2 vss_1v2 sg13_lv_nmos mm_ok=1 ad=62.5f pd=0.74u as=62.5f ps=0.74u w=0.25u l=0.5u
X110 vdd_1v2 vdd_1v2 vdd_1v2 vdd_1v2 sg13_lv_pmos mm_ok=1 ad=0.2375p pd=1.63u as=0 ps=0 w=1.25u l=0.5u
X111 vdd_1v2 ota_cmfb_top_0.dynamic_pcell_5_0.DRN_NET_CA s5_an[1] vdd_1v2 sg13_lv_pmos mm_ok=1 ad=95f pd=0.88u as=95f ps=0.88u w=0.5u l=0.5u
X112 ota_cmfb_top_0.ota_cmfb_core_push_pull_output_stage_1/dynamic_pcell_4_0.SRC_NET_ML vss_1v2 vss_1v2 vss_1v2 sg13_lv_nmos mm_ok=1 ad=0.133p pd=1.08u as=0.133p ps=1.08u w=0.7u l=0.5u
X113 vdd_1v2 ota_cmfb_top_0.dynamic_pcell_5_0.DRN_NET_CA s5_an[1] vdd_1v2 sg13_lv_pmos mm_ok=1 ad=95f pd=0.88u as=95f ps=0.88u w=0.5u l=0.5u
X114 a_58402_34440# a_58666_34154# vss_1v2 rhigh l=1u w=0.5u
X115 vdd_1v2 ota_cmfb_top_0.dynamic_pcell_5_0.DRN_NET_BD s5_an[2] vdd_1v2 sg13_lv_pmos mm_ok=1 ad=95f pd=0.88u as=95f ps=0.88u w=0.5u l=0.5u
X116 vdd_1v2 vdd_1v2 vdd_1v2 vdd_1v2 sg13_lv_pmos mm_ok=1 ad=0.475p pd=2.88u as=0 ps=0 w=2.5u l=0.5u
X117 vdd_1v2 vdd_1v2 vdd_1v2 vdd_1v2 sg13_lv_pmos mm_ok=1 ad=0.425p pd=3.18u as=0 ps=0 w=1.25u l=0.5u
X118 ota_cmfb_top_0.ota_cmfb_core_push_pull_output_stage_1/dynamic_pcell_4_0.DRN_NET_MENX vss_1v2 vss_1v2 vss_1v2 sg13_lv_nmos mm_ok=1 ad=0.133p pd=1.08u as=0.133p ps=1.08u w=0.7u l=3u
X119 ota_cmfb_top_0.ota_cmfb_core_push_pull_output_stage_1/dynamic_pcell_4_0.SRC_NET_QP_GATE_KLQ ota_cmfb_top_0.ota_cmfb_core_push_pull_output_stage_1/dynamic_pcell_4_0.DRN_NET_OP_GATE_MP ota_cmfb_top_0.ota_cmfb_core_push_pull_output_stage_1/dynamic_pcell_4_0.DRN_NET_OP_GATE_MP vss_1v2 sg13_lv_nmos mm_ok=1 ad=0.133p pd=1.08u as=0.133p ps=1.08u w=0.7u l=3u
X120 ota_cmfb_top_0.dynamic_pcell_5_0.DRN_NET_CA analog_bus0 ota_cmfb_top_0.dynamic_pcell_5_0.SRC_NET_AB vdd_1v2 sg13_lv_pmos mm_ok=1 ad=0.475p pd=2.88u as=0.85p ps=5.68u w=2.5u l=2u
X121 vss_1v2 ibias0 ota_cmfb_top_0.dynamic_pcell_5_0.DRN_NET_CA vss_1v2 sg13_lv_nmos mm_ok=1 ad=62.5f pd=0.74u as=62.5f ps=0.74u w=0.25u l=10u
X122 ota_cmfb_top_0.ota_cmfb_core_push_pull_output_stage_0/dynamic_pcell_4_0.SRC_NET_QP_GATE_KLQ ota_cmfb_top_0.ota_cmfb_core_push_pull_output_stage_0/dynamic_pcell_4_0.DRN_NET_OP_GATE_MP ota_cmfb_top_0.ota_cmfb_core_push_pull_output_stage_0/dynamic_pcell_4_0.DRN_NET_OP_GATE_MP vss_1v2 sg13_lv_nmos mm_ok=1 ad=0.133p pd=1.08u as=0.133p ps=1.08u w=0.7u l=3u
X123 vdd_1v2 vdd_1v2 vdd_1v2 vdd_1v2 sg13_lv_pmos mm_ok=1 ad=0.2375p pd=1.63u as=0 ps=0 w=1.25u l=0.5u
X124 vdd_1v2 ota_cmfb_top_0.dynamic_pcell_5_0.G_DRN ota_cmfb_top_0.dynamic_pcell_5_0.G_DRN vdd_1v2 sg13_lv_pmos mm_ok=1 ad=0.475p pd=2.88u as=0.475p ps=2.88u w=2.5u l=3u
X125 ota_cmfb_top_0.dynamic_pcell_5_0.DRN_NET_CA ota_cmfb_top_0.ota_cmfb_core_push_pull_output_stage_1/dynamic_pcell_4_0.DRN_NET_J_GATE_EJ ota_cmfb_top_0.ota_cmfb_core_push_pull_output_stage_1/dynamic_pcell_4_0.DRN_NET_MENX vdd_1v2 sg13_lv_pmos mm_ok=1 ad=0.475p pd=2.88u as=0.85p ps=5.68u w=2.5u l=3u
X126 vdd_1v2 vdd_1v2 vdd_1v2 vdd_1v2 sg13_lv_pmos mm_ok=1 ad=95f pd=0.88u as=0 ps=0 w=0.5u l=0.5u
X127 ota_cmfb_top_0.dynamic_pcell_5_0.SRC_NET_KL ota_cmfb_top_0.dynamic_pcell_5_0.H_DRN vdd_1v2 vdd_1v2 sg13_lv_pmos mm_ok=1 ad=0.2375p pd=1.63u as=0.2375p ps=1.63u w=1.25u l=5u
X128 a_50396_27979# a_50132_27693# vss_1v2 rhigh l=1u w=0.5u
X129 vss_1v2 vss_1v2 ota_cmfb_top_0.ota_cmfb_core_push_pull_output_stage_0/dynamic_pcell_4_0.DRN_NET_OP_GATE_MP vss_1v2 sg13_lv_nmos mm_ok=1 ad=0.133p pd=1.08u as=0.133p ps=1.08u w=0.7u l=0.5u
X130 ota_cmfb_top_0.ota_cmfb_core_push_pull_output_stage_1/dynamic_pcell_4_0.SRC_NET_QP_GATE_KLQ ota_cmfb_top_0.ota_cmfb_core_push_pull_output_stage_1/dynamic_pcell_4_0.DRN_NET_OP_GATE_MP ota_cmfb_top_0.ota_cmfb_core_push_pull_output_stage_1/dynamic_pcell_4_0.DRN_NET_OP_GATE_MP vss_1v2 sg13_lv_nmos mm_ok=1 ad=0.133p pd=1.08u as=0.133p ps=1.08u w=0.7u l=3u
X131 ota_cmfb_top_0.dynamic_pcell_5_0.SRC_NET_AB analog_bus0 ota_cmfb_top_0.dynamic_pcell_5_0.DRN_NET_CA vdd_1v2 sg13_lv_pmos mm_ok=1 ad=0.475p pd=2.88u as=0.475p ps=2.88u w=2.5u l=2u
X132 vdd_1v2 vdd_1v2 vdd_1v2 vdd_1v2 sg13_lv_pmos mm_ok=1 ad=0.475p pd=2.88u as=0 ps=0 w=2.5u l=0.5u
X133 vdd_1v2 vdd_1v2 vdd_1v2 vdd_1v2 sg13_lv_pmos mm_ok=1 ad=0.2375p pd=1.63u as=0 ps=0 w=1.25u l=0.5u
X134 ota_cmfb_top_0.dynamic_pcell_5_0.F_DRN vss_1v2 vss_1v2 vss_1v2 sg13_lv_nmos mm_ok=1 ad=62.5f pd=0.74u as=62.5f ps=0.74u w=0.25u l=0.5u
X135 a_58666_33917# a_58930_33631# vss_1v2 rhigh l=1u w=0.5u
X136 vdd_1v2 vdd_1v2 vdd_1v2 vdd_1v2 sg13_lv_pmos mm_ok=1 ad=0.475p pd=2.88u as=0 ps=0 w=2.5u l=0.5u
X137 vdd_1v2 vdd_1v2 vdd_1v2 vdd_1v2 sg13_lv_pmos mm_ok=1 ad=95f pd=0.88u as=0 ps=0 w=0.5u l=0.5u
X138 ota_cmfb_top_0.EN_INV_1/sg13cmos5l_inv_4_0.Y enable vss_1v2 vss_1v2 sg13_lv_nmos mm_ok=1 ad=0.1406p pd=1.12u as=0.1406p ps=1.12u w=0.74u l=0.13u
X139 ota_cmfb_top_0.ota_cmfb_core_push_pull_output_stage_1/dynamic_pcell_4_0.SRC_NET_IJ_GATE_DI ota_cmfb_top_0.ota_cmfb_core_push_pull_output_stage_1/dynamic_pcell_4_0.DRN_NET_J_GATE_EJ ota_cmfb_top_0.ota_cmfb_core_push_pull_output_stage_1/dynamic_pcell_4_0.DRN_NET_J_GATE_EJ vdd_1v2 sg13_lv_pmos mm_ok=1 ad=0.475p pd=2.88u as=0.475p ps=2.88u w=2.5u l=3u
X140 a_51669_33917# a_51669_33631# vss_1v2 rhigh l=1u w=0.5u
X141 ota_cmfb_top_0.dynamic_pcell_5_0.H_DRN vdd_1v2 vdd_1v2 vdd_1v2 sg13_lv_pmos mm_ok=1 ad=0.2375p pd=1.63u as=0.2375p ps=1.63u w=1.25u l=0.5u
X142 vdd_1v2 vdd_1v2 vdd_1v2 vdd_1v2 sg13_lv_pmos mm_ok=1 ad=95f pd=0.88u as=0 ps=0 w=0.5u l=0.5u
X143 vss_1v2 enable ota_cmfb_top_0.EN_INV_0/sg13cmos5l_inv_4_0.Y vss_1v2 sg13_lv_nmos mm_ok=1 ad=0.2516p pd=2.16u as=0.1406p ps=1.12u w=0.74u l=0.13u
X144 vdd_1v2 vdd_1v2 vdd_1v2 vdd_1v2 sg13_lv_pmos mm_ok=1 ad=0.475p pd=2.88u as=0 ps=0 w=2.5u l=0.5u
X145 ota_cmfb_top_0.ota_cmfb_core_push_pull_output_stage_1/dynamic_pcell_4_0.DRN_NET_OP_GATE_MP ota_cmfb_top_0.ota_cmfb_core_push_pull_output_stage_1/dynamic_pcell_4_0.B_DRN ota_cmfb_top_0.ota_cmfb_core_push_pull_output_stage_1/dynamic_pcell_4_0.B_DRN vss_1v2 sg13_lv_nmos mm_ok=1 ad=0.133p pd=1.08u as=0.133p ps=1.08u w=0.7u l=3u
X146 vss_1v2 vss_1v2 vss_1v2 vss_1v2 sg13_lv_nmos mm_ok=1 ad=95f pd=0.88u as=0 ps=0 w=0.5u l=0.5u
X147 ota_cmfb_top_0.dynamic_pcell_5_0.SRC_NET_AB analog_bus0 ota_cmfb_top_0.dynamic_pcell_5_0.DRN_NET_CA vdd_1v2 sg13_lv_pmos mm_ok=1 ad=0.475p pd=2.88u as=0.475p ps=2.88u w=2.5u l=2u
X148 a_50132_27418# a_50396_27132# vss_1v2 rhigh l=1u w=0.5u
X149 vss_1v2 vss_1v2 ota_cmfb_top_0.ota_cmfb_core_push_pull_output_stage_1/dynamic_pcell_4_0.DRN_NET_MENX vss_1v2 sg13_lv_nmos mm_ok=1 ad=0.133p pd=1.08u as=0.133p ps=1.08u w=0.7u l=3u
X150 ota_cmfb_top_0.dynamic_pcell_5_0.DRN_NET_JL ota_cmfb_top_0.dynamic_pcell_5_0.DRN_NET_IK_GATE_IJ vss_1v2 vss_1v2 sg13_lv_nmos mm_ok=1 ad=62.5f pd=0.74u as=62.5f ps=0.74u w=0.25u l=10u
X151 vdd_1v2 ota_cmfb_top_0.dynamic_pcell_5_0.DRN_NET_CA s5_an[1] vdd_1v2 sg13_lv_pmos mm_ok=1 ad=95f pd=0.88u as=95f ps=0.88u w=0.5u l=0.5u
X152 vdd_1v2 ota_cmfb_top_0.dynamic_pcell_5_0.G_DRN ota_cmfb_top_0.ota_cmfb_core_push_pull_output_stage_1/dynamic_pcell_4_0.DRN_NET_HI vdd_1v2 sg13_lv_pmos mm_ok=1 ad=0.475p pd=2.88u as=0.475p ps=2.88u w=2.5u l=3u
X153 ota_cmfb_top_0.dynamic_pcell_5_0.SRC_NET_KL vdd_1v2 vdd_1v2 vdd_1v2 sg13_lv_pmos mm_ok=1 ad=0.475p pd=2.88u as=0.475p ps=2.88u w=2.5u l=0.5u
X154 ota_cmfb_top_0.ota_cmfb_core_push_pull_output_stage_1/dynamic_pcell_4_0.DRN_NET_OP_GATE_MP ota_cmfb_top_0.ota_cmfb_core_push_pull_output_stage_1/dynamic_pcell_4_0.B_DRN ota_cmfb_top_0.ota_cmfb_core_push_pull_output_stage_1/dynamic_pcell_4_0.B_DRN vss_1v2 sg13_lv_nmos mm_ok=1 ad=0.133p pd=1.08u as=0.133p ps=1.08u w=0.7u l=3u
X155 s5_an[2] a_58930_33631# vss_1v2 rhigh l=1u w=0.5u
X156 vdd_1v2 vdd_1v2 vdd_1v2 vdd_1v2 sg13_lv_pmos mm_ok=1 ad=0.475p pd=2.88u as=0 ps=0 w=2.5u l=0.5u
X157 ota_cmfb_top_0.dynamic_pcell_5_0.SRC_NET_AB vdd_1v2 vdd_1v2 vdd_1v2 sg13_lv_pmos mm_ok=1 ad=0.475p pd=2.88u as=0.475p ps=2.88u w=2.5u l=0.5u
X158 vss_1v2 vss_1v2 vss_1v2 vss_1v2 sg13_lv_nmos mm_ok=1 ad=62.5f pd=0.74u as=0 ps=0 w=0.25u l=0.5u
X159 vss_1v2 vss_1v2 vss_1v2 vss_1v2 sg13_lv_nmos mm_ok=1 ad=0.133p pd=1.08u as=0 ps=0 w=0.7u l=0.5u
X160 vdd_1v2 vdd_1v2 vdd_1v2 vdd_1v2 sg13_lv_pmos mm_ok=1 ad=95f pd=0.88u as=0 ps=0 w=0.5u l=0.5u
X161 vss_1v2 enable ota_cmfb_top_0.EN_INV_1/sg13cmos5l_inv_4_0.Y vss_1v2 sg13_lv_nmos mm_ok=1 ad=0.2516p pd=2.16u as=0.1406p ps=1.12u w=0.74u l=0.13u
X162 vss_1v2 vss_1v2 vss_1v2 vss_1v2 sg13_lv_nmos mm_ok=1 ad=95f pd=0.88u as=0 ps=0 w=0.5u l=0.5u
X163 vdd_1v2 vdd_1v2 vdd_1v2 vdd_1v2 sg13_lv_pmos mm_ok=1 ad=0.2375p pd=1.63u as=0 ps=0 w=1.25u l=0.5u
X164 ota_cmfb_top_0.ota_cmfb_core_push_pull_output_stage_0/dynamic_pcell_4_0.DRN_NET_MENX ota_cmfb_top_0.ota_cmfb_core_push_pull_output_stage_0/dynamic_pcell_4_0.DRN_NET_OP_GATE_MP ota_cmfb_top_0.ota_cmfb_core_push_pull_output_stage_0/dynamic_pcell_4_0.SRC_NET_ML vss_1v2 sg13_lv_nmos mm_ok=1 ad=0.133p pd=1.08u as=0.133p ps=1.08u w=0.7u l=3u
X165 vdd_1v2 vdd_1v2 vdd_1v2 vdd_1v2 sg13_lv_pmos mm_ok=1 ad=95f pd=0.88u as=0 ps=0 w=0.5u l=0.5u
X166 vdd_1v2 vdd_1v2 vdd_1v2 vdd_1v2 sg13_lv_pmos mm_ok=1 ad=0.475p pd=2.88u as=0 ps=0 w=2.5u l=0.5u
X167 vdd_1v2 vdd_1v2 vdd_1v2 vdd_1v2 sg13_lv_pmos mm_ok=1 ad=0.85p pd=5.68u as=0 ps=0 w=2.5u l=0.5u
X168 ota_cmfb_top_0.dynamic_pcell_5_0.DRN_NET_IK_GATE_IJ s5_an[0] ota_cmfb_top_0.dynamic_pcell_5_0.SRC_NET_KL vdd_1v2 sg13_lv_pmos mm_ok=1 ad=0.85p pd=5.68u as=0.475p ps=2.88u w=2.5u l=2u
X169 vss_1v2 vss_1v2 vss_1v2 vss_1v2 sg13_lv_nmos mm_ok=1 ad=95f pd=0.88u as=0 ps=0 w=0.5u l=0.5u
X170 ota_cmfb_top_0.dynamic_pcell_5_0.DRN_NET_CA ibias0 vss_1v2 vss_1v2 sg13_lv_nmos mm_ok=1 ad=62.5f pd=0.74u as=62.5f ps=0.74u w=0.25u l=10u
X171 vdd_1v2 vdd_1v2 vdd_1v2 vdd_1v2 sg13_lv_pmos mm_ok=1 ad=0.85p pd=5.68u as=0 ps=0 w=2.5u l=0.5u
X172 ota_cmfb_top_0.ota_cmfb_core_push_pull_output_stage_1/dynamic_pcell_4_0.SRC_NET_ML vss_1v2 vss_1v2 vss_1v2 sg13_lv_nmos mm_ok=1 ad=0.133p pd=1.08u as=0.133p ps=1.08u w=0.7u l=0.5u
X173 ota_cmfb_top_0.ota_cmfb_core_push_pull_output_stage_1/dynamic_pcell_4_0.B_DRN ota_cmfb_top_0.ota_cmfb_core_push_pull_output_stage_1/dynamic_pcell_4_0.B_DRN ota_cmfb_top_0.ota_cmfb_core_push_pull_output_stage_1/dynamic_pcell_4_0.DRN_NET_OP_GATE_MP vss_1v2 sg13_lv_nmos mm_ok=1 ad=0.133p pd=1.08u as=0.133p ps=1.08u w=0.7u l=3u
X174 ota_cmfb_top_0.dynamic_pcell_5_0.DRN_NET_BD ibias0 vss_1v2 vss_1v2 sg13_lv_nmos mm_ok=1 ad=62.5f pd=0.74u as=62.5f ps=0.74u w=0.25u l=10u
X175 vdd_1v2 vdd_1v2 vdd_1v2 vdd_1v2 sg13_lv_pmos mm_ok=1 ad=0.85p pd=5.68u as=0 ps=0 w=2.5u l=0.5u
X176 ota_cmfb_top_0.ota_cmfb_core_push_pull_output_stage_1/dynamic_pcell_4_0.DRN_NET_MENX vss_1v2 vss_1v2 vss_1v2 sg13_lv_nmos mm_ok=1 ad=0.133p pd=1.08u as=0.133p ps=1.08u w=0.7u l=3u
X177 vdd_1v2 ota_cmfb_top_0.dynamic_pcell_5_0.DRN_NET_CA s5_an[1] vdd_1v2 sg13_lv_pmos mm_ok=1 ad=0.17p pd=1.68u as=95f ps=0.88u w=0.5u l=0.5u
X178 vss_1v2 vss_1v2 vss_1v2 vss_1v2 sg13_lv_nmos mm_ok=1 ad=62.5f pd=0.74u as=0 ps=0 w=0.25u l=0.5u
X179 a_49340_27979# a_49604_27693# vss_1v2 rhigh l=1u w=0.5u
X180 ota_cmfb_top_0.EN_INV_0/sg13cmos5l_inv_4_0.Y enable vdd_1v2 vdd_1v2 sg13_lv_pmos mm_ok=1 ad=0.2128p pd=1.5u as=0.3808p ps=2.92u w=1.12u l=0.13u
X181 vdd_1v2 ota_cmfb_top_0.dynamic_pcell_5_0.DRN_NET_JL ota_cmfb_top_0.dynamic_pcell_5_0.SRC_NET_AB vdd_1v2 sg13_lv_pmos mm_ok=1 ad=0.475p pd=2.88u as=0.475p ps=2.88u w=2.5u l=10u
X182 vdd_1v2 vdd_1v2 vdd_1v2 vdd_1v2 sg13_lv_pmos mm_ok=1 ad=0.475p pd=2.88u as=0 ps=0 w=2.5u l=0.5u
X183 vdd_1v2 vdd_1v2 vdd_1v2 vdd_1v2 sg13_lv_pmos mm_ok=1 ad=95f pd=0.88u as=0 ps=0 w=0.5u l=0.5u
X184 vss_1v2 vss_1v2 vss_1v2 vss_1v2 sg13_lv_nmos mm_ok=1 ad=62.5f pd=0.74u as=0 ps=0 w=0.25u l=0.5u
X185 vss_1v2 vss_1v2 vss_1v2 vss_1v2 sg13_lv_nmos mm_ok=1 ad=0.133p pd=1.08u as=0 ps=0 w=0.7u l=0.5u
X186 vss_1v2 vss_1v2 vss_1v2 vss_1v2 sg13_lv_nmos mm_ok=1 ad=0.133p pd=1.08u as=0 ps=0 w=0.7u l=0.5u
X187 vdd_1v2 vdd_1v2 vdd_1v2 vdd_1v2 sg13_lv_pmos mm_ok=1 ad=0.2375p pd=1.63u as=0 ps=0 w=1.25u l=0.5u
X188 vdd_1v2 vdd_1v2 vdd_1v2 vdd_1v2 sg13_lv_pmos mm_ok=1 ad=0.85p pd=5.68u as=0 ps=0 w=2.5u l=0.5u
X189 vss_1v2 ota_cmfb_top_0.dynamic_pcell_5_0.DRN_NET_IK_GATE_IJ ota_cmfb_top_0.dynamic_pcell_5_0.DRN_NET_JL vss_1v2 sg13_lv_nmos mm_ok=1 ad=62.5f pd=0.74u as=62.5f ps=0.74u w=0.25u l=10u
X190 vdd_1v2 ota_cmfb_top_0.dynamic_pcell_5_0.DRN_NET_BD s5_an[2] vdd_1v2 sg13_lv_pmos mm_ok=1 ad=0.17p pd=1.68u as=95f ps=0.88u w=0.5u l=0.5u
X191 ota_cmfb_top_0.dynamic_pcell_5_0.H_DRN ota_cmfb_top_0.dynamic_pcell_5_0.H_DRN vdd_1v2 vdd_1v2 sg13_lv_pmos mm_ok=1 ad=0.2375p pd=1.63u as=0.2375p ps=1.63u w=1.25u l=5u
X192 vdd_1v2 ota_cmfb_top_0.dynamic_pcell_5_0.DRN_NET_JL ota_cmfb_top_0.dynamic_pcell_5_0.SRC_NET_AB vdd_1v2 sg13_lv_pmos mm_ok=1 ad=0.475p pd=2.88u as=0.475p ps=2.88u w=2.5u l=10u
X193 vdd_1v2 vdd_1v2 vdd_1v2 vdd_1v2 sg13_lv_pmos mm_ok=1 ad=0.2375p pd=1.63u as=0 ps=0 w=1.25u l=0.5u
X194 ota_cmfb_top_0.dynamic_pcell_5_0.DRN_NET_CA ibias0 vss_1v2 vss_1v2 sg13_lv_nmos mm_ok=1 ad=62.5f pd=0.74u as=62.5f ps=0.74u w=0.25u l=10u
X195 ota_cmfb_top_0.ota_cmfb_core_push_pull_output_stage_1/dynamic_pcell_4_0.DRN_NET_OP_GATE_MP ota_cmfb_top_0.ota_cmfb_core_push_pull_output_stage_1/dynamic_pcell_4_0.DRN_NET_OP_GATE_MP ota_cmfb_top_0.ota_cmfb_core_push_pull_output_stage_1/dynamic_pcell_4_0.SRC_NET_QP_GATE_KLQ vss_1v2 sg13_lv_nmos mm_ok=1 ad=0.133p pd=1.08u as=0.133p ps=1.08u w=0.7u l=3u
X196 a_49604_27418# a_49340_27132# vss_1v2 rhigh l=1u w=0.5u
X197 vdd_1v2 vdd_1v2 vdd_1v2 vdd_1v2 sg13_lv_pmos mm_ok=1 ad=0.475p pd=2.88u as=0 ps=0 w=2.5u l=0.5u
X198 ota_cmfb_top_0.dynamic_pcell_5_0.DRN_NET_BD analog_bus1 ota_cmfb_top_0.dynamic_pcell_5_0.SRC_NET_AB vdd_1v2 sg13_lv_pmos mm_ok=1 ad=0.475p pd=2.88u as=0.475p ps=2.88u w=2.5u l=2u
X199 ota_cmfb_top_0.EN_INV_1/sg13cmos5l_inv_4_0.Y enable vdd_1v2 vdd_1v2 sg13_lv_pmos mm_ok=1 ad=0.2128p pd=1.5u as=0.3808p ps=2.92u w=1.12u l=0.13u
X200 vss_1v2 vss_1v2 vss_1v2 vss_1v2 sg13_lv_nmos mm_ok=1 ad=0.133p pd=1.08u as=0 ps=0 w=0.7u l=0.5u
X201 vdd_1v2 ota_cmfb_top_0.dynamic_pcell_5_0.DRN_NET_BD s5_an[2] vdd_1v2 sg13_lv_pmos mm_ok=1 ad=95f pd=0.88u as=95f ps=0.88u w=0.5u l=0.5u
X202 vdd_1v2 enable ota_cmfb_top_0.EN_INV_0/sg13cmos5l_inv_4_0.Y vdd_1v2 sg13_lv_pmos mm_ok=1 ad=0.2128p pd=1.5u as=0.2128p ps=1.5u w=1.12u l=0.13u
X203 vdd_1v2 vdd_1v2 vdd_1v2 vdd_1v2 sg13_lv_pmos mm_ok=1 ad=0.2375p pd=1.63u as=0 ps=0 w=1.25u l=0.5u
X204 vdd_1v2 vdd_1v2 vdd_1v2 vdd_1v2 sg13_lv_pmos mm_ok=1 ad=95f pd=0.88u as=0 ps=0 w=0.5u l=0.5u
X205 vdd_1v2 vdd_1v2 vdd_1v2 vdd_1v2 sg13_lv_pmos mm_ok=1 ad=0.475p pd=2.88u as=0 ps=0 w=2.5u l=0.5u
X206 vdd_1v2 vdd_1v2 vdd_1v2 vdd_1v2 sg13_lv_pmos mm_ok=1 ad=0.475p pd=2.88u as=0 ps=0 w=2.5u l=0.5u
X207 vdd_1v2 vdd_1v2 vdd_1v2 vdd_1v2 sg13_lv_pmos mm_ok=1 ad=0.85p pd=5.68u as=0 ps=0 w=2.5u l=0.5u
X208 ota_cmfb_top_0.dynamic_pcell_5_0.DRN_NET_BD ibias0 vss_1v2 vss_1v2 sg13_lv_nmos mm_ok=1 ad=62.5f pd=0.74u as=62.5f ps=0.74u w=0.25u l=10u
X209 vdd_1v2 vdd_1v2 vdd_1v2 vdd_1v2 sg13_lv_pmos mm_ok=1 ad=0.2375p pd=1.63u as=0 ps=0 w=1.25u l=0.5u
X210 vss_1v2 vss_1v2 vss_1v2 vss_1v2 sg13_lv_nmos mm_ok=1 ad=0.1075p pd=1.34u as=0 ps=0 w=0.25u l=0.5u
X211 vss_1v2 vss_1v2 vss_1v2 vss_1v2 sg13_lv_nmos mm_ok=1 ad=95f pd=0.88u as=0 ps=0 w=0.5u l=0.5u
X212 vdd_1v2 vdd_1v2 vdd_1v2 vdd_1v2 sg13_lv_pmos mm_ok=1 ad=0.475p pd=2.88u as=0 ps=0 w=2.5u l=0.5u
X213 vss_1v2 vss_1v2 vss_1v2 vss_1v2 sg13_lv_nmos mm_ok=1 ad=0.1075p pd=1.34u as=0 ps=0 w=0.25u l=0.5u
X214 vdd_1v2 vdd_1v2 vdd_1v2 vdd_1v2 sg13_lv_pmos mm_ok=1 ad=95f pd=0.88u as=0 ps=0 w=0.5u l=0.5u
X215 vdd_1v2 vdd_1v2 vdd_1v2 vdd_1v2 sg13_lv_pmos mm_ok=1 ad=0.475p pd=2.88u as=0 ps=0 w=2.5u l=0.5u
X216 vdd_1v2 vdd_1v2 vdd_1v2 vdd_1v2 sg13_lv_pmos mm_ok=1 ad=0.2375p pd=1.63u as=0 ps=0 w=1.25u l=0.5u
X217 ota_cmfb_top_0.dynamic_pcell_5_0.SRC_NET_AB analog_bus0 ota_cmfb_top_0.dynamic_pcell_5_0.DRN_NET_CA vdd_1v2 sg13_lv_pmos mm_ok=1 ad=0.475p pd=2.88u as=0.475p ps=2.88u w=2.5u l=2u
X218 a_58930_34440# a_58666_34154# vss_1v2 rhigh l=1u w=0.5u
X219 vdd_1v2 vdd_1v2 vdd_1v2 vdd_1v2 sg13_lv_pmos mm_ok=1 ad=0.85p pd=5.68u as=0 ps=0 w=2.5u l=0.5u
X220 ibias0 ota_cmfb_top_0.EN_INV_1/sg13cmos5l_inv_4_0.Y vss_1v2 vss_1v2 sg13_lv_nmos mm_ok=1 ad=0.2516p pd=2.16u as=0.2516p ps=2.16u w=0.74u l=0.13u
X221 vss_1v2 vss_1v2 vss_1v2 vss_1v2 sg13_lv_nmos mm_ok=1 ad=62.5f pd=0.74u as=0 ps=0 w=0.25u l=0.5u
X222 vdd_1v2 vdd_1v2 vdd_1v2 vdd_1v2 sg13_lv_pmos mm_ok=1 ad=0.85p pd=5.68u as=0 ps=0 w=2.5u l=0.5u
X223 a_51669_34440# a_51669_33917# vss_1v2 rhigh l=1u w=0.5u
X224 ota_cmfb_top_0.dynamic_pcell_5_0.SRC_NET_AB analog_bus1 ota_cmfb_top_0.dynamic_pcell_5_0.DRN_NET_BD vdd_1v2 sg13_lv_pmos mm_ok=1 ad=0.475p pd=2.88u as=0.475p ps=2.88u w=2.5u l=2u
X225 vdd_1v2 ota_cmfb_top_0.dynamic_pcell_5_0.F_DRN ota_cmfb_top_0.ota_cmfb_core_push_pull_output_stage_0/dynamic_pcell_4_0.DRN_NET_CD vdd_1v2 sg13_lv_pmos mm_ok=1 ad=0.475p pd=2.88u as=0.475p ps=2.88u w=2.5u l=3u
X226 vss_1v2 vss_1v2 vss_1v2 vss_1v2 sg13_lv_nmos mm_ok=1 ad=62.5f pd=0.74u as=0 ps=0 w=0.25u l=0.5u
X227 vdd_1v2 vdd_1v2 ota_cmfb_top_0.dynamic_pcell_5_0.SRC_NET_AB vdd_1v2 sg13_lv_pmos mm_ok=1 ad=0.475p pd=2.88u as=0.475p ps=2.88u w=2.5u l=0.5u
X228 ota_cmfb_top_0.dynamic_pcell_5_0.DRN_NET_BD ibias0 vss_1v2 vss_1v2 sg13_lv_nmos mm_ok=1 ad=62.5f pd=0.74u as=62.5f ps=0.74u w=0.25u l=10u
X229 vdd_1v2 vdd_1v2 vdd_1v2 vdd_1v2 sg13_lv_pmos mm_ok=1 ad=0.85p pd=5.68u as=0 ps=0 w=2.5u l=0.5u
X230 ota_cmfb_top_0.ota_cmfb_core_push_pull_output_stage_1/dynamic_pcell_4_0.DRN_NET_CD vdd_1v2 vdd_1v2 vdd_1v2 sg13_lv_pmos mm_ok=1 ad=0.475p pd=2.88u as=0.475p ps=2.88u w=2.5u l=0.5u
X231 ota_cmfb_top_0.dynamic_pcell_5_0.SRC_NET_AB ota_cmfb_top_0.dynamic_pcell_5_0.DRN_NET_JL vdd_1v2 vdd_1v2 sg13_lv_pmos mm_ok=1 ad=0.475p pd=2.88u as=0.475p ps=2.88u w=2.5u l=10u
X232 ota_cmfb_top_0.ota_cmfb_core_push_pull_output_stage_0/dynamic_pcell_4_0.SRC_NET_QP_GATE_KLQ ota_cmfb_top_0.ota_cmfb_core_push_pull_output_stage_0/dynamic_pcell_4_0.DRN_NET_OP_GATE_MP ota_cmfb_top_0.ota_cmfb_core_push_pull_output_stage_0/dynamic_pcell_4_0.DRN_NET_OP_GATE_MP vss_1v2 sg13_lv_nmos mm_ok=1 ad=0.133p pd=1.08u as=0.133p ps=1.08u w=0.7u l=3u
X233 vss_1v2 vss_1v2 vss_1v2 vss_1v2 sg13_lv_nmos mm_ok=1 ad=0.133p pd=1.08u as=0 ps=0 w=0.7u l=0.5u
X234 ota_cmfb_top_0.dynamic_pcell_5_0.SRC_NET_AB vdd_1v2 vdd_1v2 vdd_1v2 sg13_lv_pmos mm_ok=1 ad=0.475p pd=2.88u as=0.475p ps=2.88u w=2.5u l=0.5u
X235 ota_cmfb_top_0.ota_cmfb_core_push_pull_output_stage_0/dynamic_pcell_4_0.DRN_NET_J_GATE_EJ ota_cmfb_top_0.ota_cmfb_core_push_pull_output_stage_0/dynamic_pcell_4_0.SRC_NET_QP_GATE_KLQ vss_1v2 vss_1v2 sg13_lv_nmos mm_ok=1 ad=0.133p pd=1.08u as=0.133p ps=1.08u w=0.7u l=3u
X236 ota_cmfb_top_0.ota_cmfb_core_push_pull_output_stage_1/dynamic_pcell_4_0.DRN_NET_OP_GATE_MP vss_1v2 vss_1v2 vss_1v2 sg13_lv_nmos mm_ok=1 ad=0.133p pd=1.08u as=0.133p ps=1.08u w=0.7u l=0.5u
X237 vss_1v2 vss_1v2 vss_1v2 vss_1v2 sg13_lv_nmos mm_ok=1 ad=0.1075p pd=1.34u as=0 ps=0 w=0.25u l=0.5u
X238 a_50396_27979# a_50660_27693# vss_1v2 rhigh l=1u w=0.5u
X239 vdd_1v2 vdd_1v2 vdd_1v2 vdd_1v2 sg13_lv_pmos mm_ok=1 ad=0.2375p pd=1.63u as=0 ps=0 w=1.25u l=0.5u
X240 vdd_1v2 vdd_1v2 vdd_1v2 vdd_1v2 sg13_lv_pmos mm_ok=1 ad=95f pd=0.88u as=0 ps=0 w=0.5u l=0.5u
X241 a_51933_33917# a_51669_33631# vss_1v2 rhigh l=1u w=0.5u
X242 a_49868_27979# a_49604_27693# vss_1v2 rhigh l=1u w=0.5u
X243 a_58930_34440# w_59515_33612# vss_1v2 rhigh l=1u w=0.5u
X244 ota_cmfb_top_0.dynamic_pcell_5_0.SRC_NET_AB ota_cmfb_top_0.dynamic_pcell_5_0.DRN_NET_JL vdd_1v2 vdd_1v2 sg13_lv_pmos mm_ok=1 ad=0.475p pd=2.88u as=0.475p ps=2.88u w=2.5u l=10u
X245 ota_cmfb_top_0.ota_cmfb_core_push_pull_output_stage_0/dynamic_pcell_4_0.DRN_NET_CD ota_cmfb_top_0.dynamic_pcell_5_0.F_DRN vdd_1v2 vdd_1v2 sg13_lv_pmos mm_ok=1 ad=0.475p pd=2.88u as=0.475p ps=2.88u w=2.5u l=3u
X246 vdd_1v2 vdd_1v2 vdd_1v2 vdd_1v2 sg13_lv_pmos mm_ok=1 ad=0.85p pd=5.68u as=0 ps=0 w=2.5u l=0.5u
X247 vss_1v2 vss_1v2 vss_1v2 vss_1v2 sg13_lv_nmos mm_ok=1 ad=62.5f pd=0.74u as=0 ps=0 w=0.25u l=0.5u
X248 ota_cmfb_top_0.dynamic_pcell_5_0.DRN_NET_IK_GATE_IJ ota_cmfb_top_0.EN_INV_0/sg13cmos5l_inv_4_0.Y vss_1v2 vss_1v2 sg13_lv_nmos mm_ok=1 ad=0.2516p pd=2.16u as=0.2516p ps=2.16u w=0.74u l=0.13u
X249 ota_cmfb_top_0.dynamic_pcell_5_0.DRN_NET_CA ibias0 vss_1v2 vss_1v2 sg13_lv_nmos mm_ok=1 ad=62.5f pd=0.74u as=62.5f ps=0.74u w=0.25u l=10u
X250 vss_1v2 vss_1v2 ota_cmfb_top_0.ota_cmfb_core_push_pull_output_stage_0/dynamic_pcell_4_0.DRN_NET_MENX vss_1v2 sg13_lv_nmos mm_ok=1 ad=0.133p pd=1.08u as=0.133p ps=1.08u w=0.7u l=3u
X251 vss_1v2 vss_1v2 vss_1v2 vss_1v2 sg13_lv_nmos mm_ok=1 ad=0.17p pd=1.68u as=0 ps=0 w=0.5u l=0.5u
X252 a_50660_27418# a_50396_27132# vss_1v2 rhigh l=1u w=0.5u
X253 ota_cmfb_top_0.ota_cmfb_core_push_pull_output_stage_1/dynamic_pcell_4_0.DRN_NET_MENX vss_1v2 vss_1v2 vss_1v2 sg13_lv_nmos mm_ok=1 ad=0.133p pd=1.08u as=0.133p ps=1.08u w=0.7u l=0.5u
X254 ota_cmfb_top_0.dynamic_pcell_5_0.SRC_NET_AB analog_bus1 ota_cmfb_top_0.dynamic_pcell_5_0.DRN_NET_BD vdd_1v2 sg13_lv_pmos mm_ok=1 ad=0.85p pd=5.68u as=0.475p ps=2.88u w=2.5u l=2u
X255 vss_1v2 vss_1v2 vss_1v2 vss_1v2 sg13_lv_nmos mm_ok=1 ad=0.1075p pd=1.34u as=0 ps=0 w=0.25u l=0.5u
X256 a_48812_27979# ota_cmfb_top_0.dynamic_pcell_5_0.L_GATE vss_1v2 rhigh l=1u w=0.5u
X257 vdd_1v2 vdd_1v2 vdd_1v2 vdd_1v2 sg13_lv_pmos mm_ok=1 ad=0.475p pd=2.88u as=0 ps=0 w=2.5u l=0.5u
X258 vdd_1v2 vdd_1v2 vdd_1v2 vdd_1v2 sg13_lv_pmos mm_ok=1 ad=0.2375p pd=1.63u as=0 ps=0 w=1.25u l=0.5u
X259 a_49604_27418# a_49868_27132# vss_1v2 rhigh l=1u w=0.5u
X260 vss_1v2 ota_cmfb_top_0.ota_cmfb_core_push_pull_output_stage_0/dynamic_pcell_4_0.DRN_NET_MENX s5_an[2] vss_1v2 sg13_lv_nmos mm_ok=1 ad=0.17p pd=1.68u as=0.17p ps=1.68u w=0.5u l=10u
X261 a_51933_33917# a_52197_33631# vss_1v2 rhigh l=1u w=0.5u
X262 vss_1v2 vss_1v2 vss_1v2 vss_1v2 sg13_lv_nmos mm_ok=1 ad=95f pd=0.88u as=0 ps=0 w=0.5u l=0.5u
X263 ota_cmfb_top_0.ota_cmfb_core_push_pull_output_stage_0/dynamic_pcell_4_0.B_DRN ota_cmfb_top_0.dynamic_pcell_5_0.F_DRN vdd_1v2 vdd_1v2 sg13_lv_pmos mm_ok=1 ad=0.475p pd=2.88u as=0.475p ps=2.88u w=2.5u l=3u
X264 vss_1v2 vss_1v2 vss_1v2 vss_1v2 sg13_lv_nmos mm_ok=1 ad=62.5f pd=0.74u as=0 ps=0 w=0.25u l=0.5u
X265 ota_cmfb_top_0.dynamic_pcell_5_0.DRN_NET_BD analog_bus1 ota_cmfb_top_0.dynamic_pcell_5_0.SRC_NET_AB vdd_1v2 sg13_lv_pmos mm_ok=1 ad=0.475p pd=2.88u as=0.475p ps=2.88u w=2.5u l=2u
X266 ota_cmfb_top_0.ota_cmfb_core_push_pull_output_stage_0/dynamic_pcell_4_0.B_DRN ota_cmfb_top_0.ota_cmfb_core_push_pull_output_stage_0/dynamic_pcell_4_0.B_DRN ota_cmfb_top_0.ota_cmfb_core_push_pull_output_stage_0/dynamic_pcell_4_0.DRN_NET_OP_GATE_MP vss_1v2 sg13_lv_nmos mm_ok=1 ad=0.133p pd=1.08u as=0.133p ps=1.08u w=0.7u l=3u
X267 vss_1v2 vss_1v2 vss_1v2 vss_1v2 sg13_lv_nmos mm_ok=1 ad=95f pd=0.88u as=0 ps=0 w=0.5u l=0.5u
X268 vdd_1v2 vdd_1v2 vdd_1v2 vdd_1v2 sg13_lv_pmos mm_ok=1 ad=0.475p pd=2.88u as=0 ps=0 w=2.5u l=0.5u
X269 ota_cmfb_top_0.dynamic_pcell_5_0.SRC_NET_KL ota_cmfb_top_0.dynamic_pcell_5_0.H_DRN vdd_1v2 vdd_1v2 sg13_lv_pmos mm_ok=1 ad=0.2375p pd=1.63u as=0.2375p ps=1.63u w=1.25u l=5u
X270 ota_cmfb_top_0.EN_INV_0/sg13cmos5l_inv_4_0.Y enable vss_1v2 vss_1v2 sg13_lv_nmos mm_ok=1 ad=0.1406p pd=1.12u as=0.2516p ps=2.16u w=0.74u l=0.13u
X271 vdd_1v2 vdd_1v2 vdd_1v2 vdd_1v2 sg13_lv_pmos mm_ok=1 ad=0.475p pd=2.88u as=0 ps=0 w=2.5u l=0.5u
X272 vdd_1v2 vdd_1v2 vdd_1v2 vdd_1v2 sg13_lv_pmos mm_ok=1 ad=0.475p pd=2.88u as=0 ps=0 w=2.5u l=0.5u
X273 vss_1v2 vss_1v2 vss_1v2 vss_1v2 sg13_lv_nmos mm_ok=1 ad=95f pd=0.88u as=0 ps=0 w=0.5u l=0.5u
X274 ota_cmfb_top_0.dynamic_pcell_5_0.DRN_NET_CA analog_bus0 ota_cmfb_top_0.dynamic_pcell_5_0.SRC_NET_AB vdd_1v2 sg13_lv_pmos mm_ok=1 ad=0.475p pd=2.88u as=0.475p ps=2.88u w=2.5u l=2u
X275 ota_cmfb_top_0.ota_cmfb_core_push_pull_output_stage_1/dynamic_pcell_4_0.DRN_NET_OP_GATE_MP vss_1v2 vss_1v2 vss_1v2 sg13_lv_nmos mm_ok=1 ad=0.133p pd=1.08u as=0.133p ps=1.08u w=0.7u l=0.5u
X276 vss_1v2 ota_cmfb_top_0.dynamic_pcell_5_0.DRN_NET_IK_GATE_IJ ota_cmfb_top_0.dynamic_pcell_5_0.DRN_NET_IK_GATE_IJ vss_1v2 sg13_lv_nmos mm_ok=1 ad=62.5f pd=0.74u as=62.5f ps=0.74u w=0.25u l=10u
X277 vdd_1v2 vdd_1v2 vdd_1v2 vdd_1v2 sg13_lv_pmos mm_ok=1 ad=0.475p pd=2.88u as=0 ps=0 w=2.5u l=0.5u
X278 ota_cmfb_top_0.dynamic_pcell_5_0.L_GATE a_48812_27132# vss_1v2 rhigh l=1u w=0.5u
X279 vdd_1v2 vdd_1v2 vdd_1v2 vdd_1v2 sg13_lv_pmos mm_ok=1 ad=0.475p pd=2.88u as=0 ps=0 w=2.5u l=0.5u
X280 vss_1v2 vss_1v2 vss_1v2 vss_1v2 sg13_lv_nmos mm_ok=1 ad=0.1075p pd=1.34u as=0 ps=0 w=0.25u l=0.5u
X281 a_48812_27979# a_49076_27693# vss_1v2 rhigh l=1u w=0.5u
X282 vdd_1v2 vdd_1v2 vdd_1v2 vdd_1v2 sg13_lv_pmos mm_ok=1 ad=0.475p pd=2.88u as=0 ps=0 w=2.5u l=0.5u
X283 ota_cmfb_top_0.dynamic_pcell_5_0.DRN_NET_BD ota_cmfb_top_0.ota_cmfb_core_push_pull_output_stage_0/dynamic_pcell_4_0.DRN_NET_J_GATE_EJ ota_cmfb_top_0.ota_cmfb_core_push_pull_output_stage_0/dynamic_pcell_4_0.DRN_NET_MENX vdd_1v2 sg13_lv_pmos mm_ok=1 ad=0.85p pd=5.68u as=0.475p ps=2.88u w=2.5u l=3u
X284 vdd_1v2 vdd_1v2 vdd_1v2 vdd_1v2 sg13_lv_pmos mm_ok=1 ad=95f pd=0.88u as=0 ps=0 w=0.5u l=0.5u
X285 vdd_1v2 ota_cmfb_top_0.dynamic_pcell_5_0.F_DRN ota_cmfb_top_0.dynamic_pcell_5_0.F_DRN vdd_1v2 sg13_lv_pmos mm_ok=1 ad=0.475p pd=2.88u as=0.475p ps=2.88u w=2.5u l=3u
X286 vss_1v2 vss_1v2 ota_cmfb_top_0.ota_cmfb_core_push_pull_output_stage_1/dynamic_pcell_4_0.SRC_NET_ML vss_1v2 sg13_lv_nmos mm_ok=1 ad=0.133p pd=1.08u as=0.133p ps=1.08u w=0.7u l=0.5u
X287 ota_cmfb_top_0.ota_cmfb_core_push_pull_output_stage_1/dynamic_pcell_4_0.DRN_NET_MENX vdd_1v2 vdd_1v2 vdd_1v2 sg13_lv_pmos mm_ok=1 ad=0.475p pd=2.88u as=0.475p ps=2.88u w=2.5u l=0.5u
X288 vdd_1v2 ota_cmfb_top_0.dynamic_pcell_5_0.F_DRN ota_cmfb_top_0.ota_cmfb_core_push_pull_output_stage_0/dynamic_pcell_4_0.B_DRN vdd_1v2 sg13_lv_pmos mm_ok=1 ad=0.85p pd=5.68u as=0.475p ps=2.88u w=2.5u l=3u
X289 ota_cmfb_top_0.dynamic_pcell_5_0.G_DRN vdd_1v2 vdd_1v2 vdd_1v2 sg13_lv_pmos mm_ok=1 ad=0.475p pd=2.88u as=0.475p ps=2.88u w=2.5u l=0.5u
X290 vss_1v2 vss_1v2 vss_1v2 vss_1v2 sg13_lv_nmos mm_ok=1 ad=62.5f pd=0.74u as=0 ps=0 w=0.25u l=0.5u
X291 ota_cmfb_top_0.ota_cmfb_core_push_pull_output_stage_0/dynamic_pcell_4_0.SRC_NET_ML ota_cmfb_top_0.ota_cmfb_core_push_pull_output_stage_0/dynamic_pcell_4_0.DRN_NET_OP_GATE_MP ota_cmfb_top_0.ota_cmfb_core_push_pull_output_stage_0/dynamic_pcell_4_0.DRN_NET_MENX vss_1v2 sg13_lv_nmos mm_ok=1 ad=0.133p pd=1.08u as=0.133p ps=1.08u w=0.7u l=3u
X292 ota_cmfb_top_0.ota_cmfb_core_push_pull_output_stage_0/dynamic_pcell_4_0.DRN_NET_HI ota_cmfb_top_0.dynamic_pcell_5_0.F_DRN vdd_1v2 vdd_1v2 sg13_lv_pmos mm_ok=1 ad=0.475p pd=2.88u as=0.475p ps=2.88u w=2.5u l=3u
X293 vss_1v2 ibias0 ota_cmfb_top_0.dynamic_pcell_5_0.DRN_NET_BD vss_1v2 sg13_lv_nmos mm_ok=1 ad=62.5f pd=0.74u as=62.5f ps=0.74u w=0.25u l=10u
X294 s5_an[2] ota_cmfb_top_0.dynamic_pcell_5_0.DRN_NET_BD vdd_1v2 vdd_1v2 sg13_lv_pmos mm_ok=1 ad=95f pd=0.88u as=95f ps=0.88u w=0.5u l=0.5u
X295 ota_cmfb_top_0.dynamic_pcell_5_0.SRC_NET_KL ota_cmfb_top_0.dynamic_pcell_5_0.H_DRN vdd_1v2 vdd_1v2 sg13_lv_pmos mm_ok=1 ad=0.2375p pd=1.63u as=0.2375p ps=1.63u w=1.25u l=5u
X296 vdd_1v2 vdd_1v2 vdd_1v2 vdd_1v2 sg13_lv_pmos mm_ok=1 ad=0.475p pd=2.88u as=0 ps=0 w=2.5u l=0.5u
X297 vss_1v2 ibias0 ota_cmfb_top_0.dynamic_pcell_5_0.DRN_NET_CA vss_1v2 sg13_lv_nmos mm_ok=1 ad=62.5f pd=0.74u as=62.5f ps=0.74u w=0.25u l=10u
X298 ota_cmfb_top_0.EN_INV_1/sg13cmos5l_inv_4_0.Y enable vss_1v2 vss_1v2 sg13_lv_nmos mm_ok=1 ad=0.1406p pd=1.12u as=0.2516p ps=2.16u w=0.74u l=0.13u
X299 vdd_1v2 vdd_1v2 vdd_1v2 vdd_1v2 sg13_lv_pmos mm_ok=1 ad=0.2375p pd=1.63u as=0 ps=0 w=1.25u l=0.5u
X300 vdd_1v2 vdd_1v2 vdd_1v2 vdd_1v2 sg13_lv_pmos mm_ok=1 ad=0.475p pd=2.88u as=0 ps=0 w=2.5u l=0.5u
X301 a_49076_27418# a_48812_27132# vss_1v2 rhigh l=1u w=0.5u
X302 vss_1v2 ota_cmfb_top_0.ota_cmfb_core_push_pull_output_stage_1/dynamic_pcell_4_0.DRN_NET_MENX s5_an[1] vss_1v2 sg13_lv_nmos mm_ok=1 ad=0.17p pd=1.68u as=0.17p ps=1.68u w=0.5u l=10u
X303 vss_1v2 enable ota_cmfb_top_0.EN_INV_0/sg13cmos5l_inv_4_0.Y vss_1v2 sg13_lv_nmos mm_ok=1 ad=0.1406p pd=1.12u as=0.1406p ps=1.12u w=0.74u l=0.13u
X304 vss_1v2 vss_1v2 vss_1v2 vss_1v2 sg13_lv_nmos mm_ok=1 ad=0.133p pd=1.08u as=0 ps=0 w=0.7u l=0.5u
X305 vss_1v2 vss_1v2 vss_1v2 vss_1v2 sg13_lv_nmos mm_ok=1 ad=0.238p pd=2.08u as=0 ps=0 w=0.7u l=0.5u
X306 vss_1v2 vss_1v2 vss_1v2 vss_1v2 sg13_lv_nmos mm_ok=1 ad=0.1075p pd=1.34u as=0 ps=0 w=0.25u l=0.5u
X307 ota_cmfb_top_0.dynamic_pcell_5_0.F_DRN ota_cmfb_top_0.dynamic_pcell_5_0.F_DRN vdd_1v2 vdd_1v2 sg13_lv_pmos mm_ok=1 ad=0.475p pd=2.88u as=0.475p ps=2.88u w=2.5u l=3u
X308 s5_an[1] ota_cmfb_top_0.dynamic_pcell_5_0.DRN_NET_CA vdd_1v2 vdd_1v2 sg13_lv_pmos mm_ok=1 ad=95f pd=0.88u as=95f ps=0.88u w=0.5u l=0.5u
X309 vss_1v2 vss_1v2 vss_1v2 vss_1v2 sg13_lv_nmos mm_ok=1 ad=95f pd=0.88u as=0 ps=0 w=0.5u l=0.5u
X310 ota_cmfb_top_0.ota_cmfb_core_push_pull_output_stage_0/dynamic_pcell_4_0.DRN_NET_J_GATE_EJ ota_cmfb_top_0.ota_cmfb_core_push_pull_output_stage_0/dynamic_pcell_4_0.DRN_NET_J_GATE_EJ ota_cmfb_top_0.ota_cmfb_core_push_pull_output_stage_0/dynamic_pcell_4_0.SRC_NET_IJ_GATE_DI vdd_1v2 sg13_lv_pmos mm_ok=1 ad=0.475p pd=2.88u as=0.475p ps=2.88u w=2.5u l=3u
X311 vdd_1v2 vdd_1v2 vdd_1v2 vdd_1v2 sg13_lv_pmos mm_ok=1 ad=95f pd=0.88u as=0 ps=0 w=0.5u l=0.5u
X312 s5_an[2] ota_cmfb_top_0.dynamic_pcell_5_0.DRN_NET_BD vdd_1v2 vdd_1v2 sg13_lv_pmos mm_ok=1 ad=95f pd=0.88u as=0.17p ps=1.68u w=0.5u l=0.5u
X313 vss_1v2 vss_1v2 vss_1v2 vss_1v2 sg13_lv_nmos mm_ok=1 ad=95f pd=0.88u as=0 ps=0 w=0.5u l=0.5u
X314 vss_1v2 vss_1v2 vss_1v2 vss_1v2 sg13_lv_nmos mm_ok=1 ad=95f pd=0.88u as=0 ps=0 w=0.5u l=0.5u
X315 vdd_1v2 vdd_1v2 vdd_1v2 vdd_1v2 sg13_lv_pmos mm_ok=1 ad=95f pd=0.88u as=0 ps=0 w=0.5u l=0.5u
X316 vdd_1v2 vdd_1v2 vdd_1v2 vdd_1v2 sg13_lv_pmos mm_ok=1 ad=0.85p pd=5.68u as=0 ps=0 w=2.5u l=0.5u
X317 vdd_1v2 ota_cmfb_top_0.dynamic_pcell_5_0.F_DRN ota_cmfb_top_0.ota_cmfb_core_push_pull_output_stage_0/dynamic_pcell_4_0.DRN_NET_HI vdd_1v2 sg13_lv_pmos mm_ok=1 ad=0.85p pd=5.68u as=0.475p ps=2.88u w=2.5u l=3u
X318 ota_cmfb_top_0.ota_cmfb_core_push_pull_output_stage_1/dynamic_pcell_4_0.SRC_NET_IJ_GATE_DI vdd_1v2 vdd_1v2 vdd_1v2 sg13_lv_pmos mm_ok=1 ad=0.475p pd=2.88u as=0.475p ps=2.88u w=2.5u l=0.5u
X319 vdd_1v2 vdd_1v2 vdd_1v2 vdd_1v2 sg13_lv_pmos mm_ok=1 ad=95f pd=0.88u as=0 ps=0 w=0.5u l=0.5u
X320 vss_1v2 vss_1v2 vss_1v2 vss_1v2 sg13_lv_nmos mm_ok=1 ad=62.5f pd=0.74u as=0 ps=0 w=0.25u l=0.5u
X321 ota_cmfb_top_0.ota_cmfb_core_push_pull_output_stage_0/dynamic_pcell_4_0.SRC_NET_ML ota_cmfb_top_0.ota_cmfb_core_push_pull_output_stage_0/dynamic_pcell_4_0.DRN_NET_OP_GATE_MP ota_cmfb_top_0.ota_cmfb_core_push_pull_output_stage_0/dynamic_pcell_4_0.DRN_NET_MENX vss_1v2 sg13_lv_nmos mm_ok=1 ad=0.133p pd=1.08u as=0.133p ps=1.08u w=0.7u l=3u
X322 vdd_1v2 vdd_1v2 vdd_1v2 vdd_1v2 sg13_lv_pmos mm_ok=1 ad=95f pd=0.88u as=0 ps=0 w=0.5u l=0.5u
X323 vss_1v2 vss_1v2 vss_1v2 vss_1v2 sg13_lv_nmos mm_ok=1 ad=0.1075p pd=1.34u as=0 ps=0 w=0.25u l=0.5u
X324 ota_cmfb_top_0.ota_cmfb_core_push_pull_output_stage_1/dynamic_pcell_4_0.DRN_NET_CD ota_cmfb_top_0.dynamic_pcell_5_0.G_DRN vdd_1v2 vdd_1v2 sg13_lv_pmos mm_ok=1 ad=0.475p pd=2.88u as=0.475p ps=2.88u w=2.5u l=3u
X325 vss_1v2 vss_1v2 vss_1v2 vss_1v2 sg13_lv_nmos mm_ok=1 ad=0.133p pd=1.08u as=0 ps=0 w=0.7u l=0.5u
X326 vss_1v2 vss_1v2 vss_1v2 vss_1v2 sg13_lv_nmos mm_ok=1 ad=0.1075p pd=1.34u as=0 ps=0 w=0.25u l=0.5u
X327 vdd_1v2 vdd_1v2 vdd_1v2 vdd_1v2 sg13_lv_pmos mm_ok=1 ad=0.475p pd=2.88u as=0 ps=0 w=2.5u l=0.5u
X328 ota_cmfb_top_0.ota_cmfb_core_push_pull_output_stage_0/dynamic_pcell_4_0.SRC_NET_ML ota_cmfb_top_0.ota_cmfb_core_push_pull_output_stage_0/dynamic_pcell_4_0.SRC_NET_QP_GATE_KLQ vss_1v2 vss_1v2 sg13_lv_nmos mm_ok=1 ad=0.133p pd=1.08u as=0.133p ps=1.08u w=0.7u l=3u
X329 vdd_1v2 vdd_1v2 vdd_1v2 vdd_1v2 sg13_lv_pmos mm_ok=1 ad=0.2375p pd=1.63u as=0 ps=0 w=1.25u l=0.5u
X330 ota_cmfb_top_0.ota_cmfb_core_push_pull_output_stage_0/dynamic_pcell_4_0.SRC_NET_IJ_GATE_DI ota_cmfb_top_0.ota_cmfb_core_push_pull_output_stage_0/dynamic_pcell_4_0.DRN_NET_J_GATE_EJ ota_cmfb_top_0.ota_cmfb_core_push_pull_output_stage_0/dynamic_pcell_4_0.DRN_NET_J_GATE_EJ vdd_1v2 sg13_lv_pmos mm_ok=1 ad=0.475p pd=2.88u as=0.475p ps=2.88u w=2.5u l=3u
X331 s5_an[1] ota_cmfb_top_0.dynamic_pcell_5_0.DRN_NET_CA vdd_1v2 vdd_1v2 sg13_lv_pmos mm_ok=1 ad=95f pd=0.88u as=95f ps=0.88u w=0.5u l=0.5u
X332 vss_1v2 vss_1v2 vss_1v2 vss_1v2 sg13_lv_nmos mm_ok=1 ad=0.238p pd=2.08u as=0 ps=0 w=0.7u l=0.5u
X333 vdd_1v2 enable ota_cmfb_top_0.EN_INV_1/sg13cmos5l_inv_4_0.Y vdd_1v2 sg13_lv_pmos mm_ok=1 ad=0.2128p pd=1.5u as=0.2128p ps=1.5u w=1.12u l=0.13u
X334 ota_cmfb_top_0.dynamic_pcell_5_0.SRC_NET_AB analog_bus1 ota_cmfb_top_0.dynamic_pcell_5_0.DRN_NET_BD vdd_1v2 sg13_lv_pmos mm_ok=1 ad=0.475p pd=2.88u as=0.475p ps=2.88u w=2.5u l=2u
X335 ota_cmfb_top_0.ota_cmfb_core_push_pull_output_stage_1/dynamic_pcell_4_0.DRN_NET_MENX ota_cmfb_top_0.ota_cmfb_core_push_pull_output_stage_1/dynamic_pcell_4_0.DRN_NET_OP_GATE_MP ota_cmfb_top_0.ota_cmfb_core_push_pull_output_stage_1/dynamic_pcell_4_0.SRC_NET_ML vss_1v2 sg13_lv_nmos mm_ok=1 ad=0.133p pd=1.08u as=0.133p ps=1.08u w=0.7u l=3u
X336 vss_1v2 vss_1v2 vss_1v2 vss_1v2 sg13_lv_nmos mm_ok=1 ad=62.5f pd=0.74u as=0 ps=0 w=0.25u l=0.5u
X337 vdd_1v2 ota_cmfb_top_0.dynamic_pcell_5_0.F_DRN ota_cmfb_top_0.dynamic_pcell_5_0.F_DRN vdd_1v2 sg13_lv_pmos mm_ok=1 ad=0.475p pd=2.88u as=0.85p ps=5.68u w=2.5u l=3u
X338 vss_1v2 vss_1v2 vss_1v2 vss_1v2 sg13_lv_nmos mm_ok=1 ad=95f pd=0.88u as=0 ps=0 w=0.5u l=0.5u
X339 ota_cmfb_top_0.EN_INV_0/sg13cmos5l_inv_4_0.Y enable vdd_1v2 vdd_1v2 sg13_lv_pmos mm_ok=1 ad=0.2128p pd=1.5u as=0.2128p ps=1.5u w=1.12u l=0.13u
X340 a_51669_34440# a_51933_34154# vss_1v2 rhigh l=1u w=0.5u
X341 ota_cmfb_top_0.dynamic_pcell_5_0.DRN_NET_IK_GATE_IJ s5_an[0] ota_cmfb_top_0.dynamic_pcell_5_0.SRC_NET_KL vdd_1v2 sg13_lv_pmos mm_ok=1 ad=0.475p pd=2.88u as=0.85p ps=5.68u w=2.5u l=2u
X342 ota_cmfb_top_0.ota_cmfb_core_push_pull_output_stage_0/dynamic_pcell_4_0.DRN_NET_CD ota_cmfb_top_0.ota_cmfb_core_push_pull_output_stage_0/dynamic_pcell_4_0.SRC_NET_IJ_GATE_DI ota_cmfb_top_0.dynamic_pcell_5_0.DRN_NET_BD vdd_1v2 sg13_lv_pmos mm_ok=1 ad=0.85p pd=5.68u as=0.475p ps=2.88u w=2.5u l=3u
X343 vss_1v2 vss_1v2 vss_1v2 vss_1v2 sg13_lv_nmos mm_ok=1 ad=62.5f pd=0.74u as=0 ps=0 w=0.25u l=0.5u
X344 ota_cmfb_top_0.dynamic_pcell_5_0.SRC_NET_AB analog_bus0 ota_cmfb_top_0.dynamic_pcell_5_0.DRN_NET_CA vdd_1v2 sg13_lv_pmos mm_ok=1 ad=0.85p pd=5.68u as=0.475p ps=2.88u w=2.5u l=2u
X345 vss_1v2 vss_1v2 ota_cmfb_top_0.ota_cmfb_core_push_pull_output_stage_1/dynamic_pcell_4_0.SRC_NET_ML vss_1v2 sg13_lv_nmos mm_ok=1 ad=0.133p pd=1.08u as=0.133p ps=1.08u w=0.7u l=0.5u
X346 vdd_1v2 vdd_1v2 vdd_1v2 vdd_1v2 sg13_lv_pmos mm_ok=1 ad=0.2375p pd=1.63u as=0 ps=0 w=1.25u l=0.5u
X347 vss_1v2 vss_1v2 vss_1v2 vss_1v2 sg13_lv_nmos mm_ok=1 ad=0.133p pd=1.08u as=0 ps=0 w=0.7u l=0.5u
X348 vdd_1v2 vdd_1v2 vdd_1v2 vdd_1v2 sg13_lv_pmos mm_ok=1 ad=95f pd=0.88u as=0 ps=0 w=0.5u l=0.5u
X349 vdd_1v2 vdd_1v2 vdd_1v2 vdd_1v2 sg13_lv_pmos mm_ok=1 ad=95f pd=0.88u as=0 ps=0 w=0.5u l=0.5u
X350 vdd_1v2 vdd_1v2 vdd_1v2 vdd_1v2 sg13_lv_pmos mm_ok=1 ad=95f pd=0.88u as=0 ps=0 w=0.5u l=0.5u
X351 ota_cmfb_top_0.ota_cmfb_core_push_pull_output_stage_0/dynamic_pcell_4_0.DRN_NET_MENX ota_cmfb_top_0.ota_cmfb_core_push_pull_output_stage_0/dynamic_pcell_4_0.DRN_NET_OP_GATE_MP ota_cmfb_top_0.ota_cmfb_core_push_pull_output_stage_0/dynamic_pcell_4_0.SRC_NET_ML vss_1v2 sg13_lv_nmos mm_ok=1 ad=0.133p pd=1.08u as=0.133p ps=1.08u w=0.7u l=3u
X352 vdd_1v2 vdd_1v2 vdd_1v2 vdd_1v2 sg13_lv_pmos mm_ok=1 ad=95f pd=0.88u as=0 ps=0 w=0.5u l=0.5u
X353 w_59515_33612# ota_cmfb_top_0.dynamic_pcell_5_0.DRN_NET_BD w_59515_33612# w_59515_33612# sg13_lv_pmos mm_ok=1 ad=7.31p pd=43.68u as=50.04169p ps=0.10913m w=21.5u l=3.5u
X354 vdd_1v2 vdd_1v2 vdd_1v2 vdd_1v2 sg13_lv_pmos mm_ok=1 ad=0.85p pd=5.68u as=0 ps=0 w=2.5u l=0.5u
X355 vdd_1v2 vdd_1v2 vdd_1v2 vdd_1v2 sg13_lv_pmos mm_ok=1 ad=0.2375p pd=1.63u as=0 ps=0 w=1.25u l=0.5u
X356 ota_cmfb_top_0.dynamic_pcell_5_0.DRN_NET_JL ota_cmfb_top_0.dynamic_pcell_5_0.DRN_NET_IK_GATE_IJ vss_1v2 vss_1v2 sg13_lv_nmos mm_ok=1 ad=62.5f pd=0.74u as=62.5f ps=0.74u w=0.25u l=10u
X357 vdd_1v2 ota_cmfb_top_0.dynamic_pcell_5_0.H_DRN ota_cmfb_top_0.dynamic_pcell_5_0.SRC_NET_KL vdd_1v2 sg13_lv_pmos mm_ok=1 ad=0.2375p pd=1.63u as=0.2375p ps=1.63u w=1.25u l=5u
X358 vdd_1v2 vdd_1v2 vdd_1v2 vdd_1v2 sg13_lv_pmos mm_ok=1 ad=95f pd=0.88u as=0 ps=0 w=0.5u l=0.5u
X359 ota_cmfb_top_0.dynamic_pcell_5_0.DRN_NET_BD analog_bus1 ota_cmfb_top_0.dynamic_pcell_5_0.SRC_NET_AB vdd_1v2 sg13_lv_pmos mm_ok=1 ad=0.475p pd=2.88u as=0.85p ps=5.68u w=2.5u l=2u
X360 vss_1v2 vss_1v2 vss_1v2 vss_1v2 sg13_lv_nmos mm_ok=1 ad=0.17p pd=1.68u as=0 ps=0 w=0.5u l=0.5u
X361 vss_1v2 ibias0 ota_cmfb_top_0.dynamic_pcell_5_0.G_DRN vss_1v2 sg13_lv_nmos mm_ok=1 ad=62.5f pd=0.74u as=62.5f ps=0.74u w=0.25u l=10u
X362 a_52197_34440# a_51933_34154# vss_1v2 rhigh l=1u w=0.5u
X363 vdd_1v2 ota_cmfb_top_0.dynamic_pcell_5_0.F_DRN ota_cmfb_top_0.ota_cmfb_core_push_pull_output_stage_0/dynamic_pcell_4_0.B_DRN vdd_1v2 sg13_lv_pmos mm_ok=1 ad=0.475p pd=2.88u as=0.475p ps=2.88u w=2.5u l=3u
X364 vdd_1v2 vdd_1v2 vdd_1v2 vdd_1v2 sg13_lv_pmos mm_ok=1 ad=0.475p pd=2.88u as=0 ps=0 w=2.5u l=0.5u
X365 vss_1v2 vss_1v2 vss_1v2 vss_1v2 sg13_lv_nmos mm_ok=1 ad=0.238p pd=2.08u as=0 ps=0 w=0.7u l=0.5u
X366 vss_1v2 vss_1v2 vss_1v2 vss_1v2 sg13_lv_nmos mm_ok=1 ad=95f pd=0.88u as=0 ps=0 w=0.5u l=0.5u
X367 vss_1v2 ota_cmfb_top_0.ota_cmfb_core_push_pull_output_stage_0/dynamic_pcell_4_0.SRC_NET_QP_GATE_KLQ ota_cmfb_top_0.ota_cmfb_core_push_pull_output_stage_0/dynamic_pcell_4_0.SRC_NET_QP_GATE_KLQ vss_1v2 sg13_lv_nmos mm_ok=1 ad=0.133p pd=1.08u as=0.133p ps=1.08u w=0.7u l=3u
X368 vdd_1v2 vdd_1v2 vdd_1v2 vdd_1v2 sg13_lv_pmos mm_ok=1 ad=0.85p pd=5.68u as=0 ps=0 w=2.5u l=0.5u
X369 ota_cmfb_top_0.ota_cmfb_core_push_pull_output_stage_1/dynamic_pcell_4_0.SRC_NET_ML ota_cmfb_top_0.ota_cmfb_core_push_pull_output_stage_1/dynamic_pcell_4_0.SRC_NET_QP_GATE_KLQ vss_1v2 vss_1v2 sg13_lv_nmos mm_ok=1 ad=0.133p pd=1.08u as=0.133p ps=1.08u w=0.7u l=3u
X370 vss_1v2 ota_cmfb_top_0.dynamic_pcell_5_0.DRN_NET_IK_GATE_IJ ota_cmfb_top_0.dynamic_pcell_5_0.DRN_NET_IK_GATE_IJ vss_1v2 sg13_lv_nmos mm_ok=1 ad=62.5f pd=0.74u as=62.5f ps=0.74u w=0.25u l=10u
X371 vdd_1v2 ota_cmfb_top_0.dynamic_pcell_5_0.G_DRN ota_cmfb_top_0.ota_cmfb_core_push_pull_output_stage_1/dynamic_pcell_4_0.B_DRN vdd_1v2 sg13_lv_pmos mm_ok=1 ad=0.85p pd=5.68u as=0.475p ps=2.88u w=2.5u l=3u
X372 s5_an[1] ota_cmfb_top_0.dynamic_pcell_5_0.DRN_NET_CA vdd_1v2 vdd_1v2 sg13_lv_pmos mm_ok=1 ad=95f pd=0.88u as=95f ps=0.88u w=0.5u l=0.5u
X373 ota_cmfb_top_0.dynamic_pcell_5_0.F_DRN ibias0 vss_1v2 vss_1v2 sg13_lv_nmos mm_ok=1 ad=62.5f pd=0.74u as=62.5f ps=0.74u w=0.25u l=10u
X374 vdd_1v2 vdd_1v2 ota_cmfb_top_0.ota_cmfb_core_push_pull_output_stage_1/dynamic_pcell_4_0.DRN_NET_CD vdd_1v2 sg13_lv_pmos mm_ok=1 ad=0.475p pd=2.88u as=0.475p ps=2.88u w=2.5u l=0.5u
X375 ota_cmfb_top_0.dynamic_pcell_5_0.DRN_NET_JL ota_cmfb_top_0.dynamic_pcell_5_0.L_GATE ota_cmfb_top_0.dynamic_pcell_5_0.SRC_NET_KL vdd_1v2 sg13_lv_pmos mm_ok=1 ad=0.85p pd=5.68u as=0.475p ps=2.88u w=2.5u l=2u
X376 vdd_1v2 vdd_1v2 vdd_1v2 vdd_1v2 sg13_lv_pmos mm_ok=1 ad=0.2375p pd=1.63u as=0 ps=0 w=1.25u l=0.5u
X377 ota_cmfb_top_0.ota_cmfb_core_push_pull_output_stage_0/dynamic_pcell_4_0.SRC_NET_ML ota_cmfb_top_0.ota_cmfb_core_push_pull_output_stage_0/dynamic_pcell_4_0.SRC_NET_QP_GATE_KLQ vss_1v2 vss_1v2 sg13_lv_nmos mm_ok=1 ad=0.133p pd=1.08u as=0.133p ps=1.08u w=0.7u l=3u
X378 ota_cmfb_top_0.ota_cmfb_core_push_pull_output_stage_1/dynamic_pcell_4_0.DRN_NET_CD ota_cmfb_top_0.ota_cmfb_core_push_pull_output_stage_1/dynamic_pcell_4_0.SRC_NET_IJ_GATE_DI ota_cmfb_top_0.dynamic_pcell_5_0.DRN_NET_CA vdd_1v2 sg13_lv_pmos mm_ok=1 ad=0.85p pd=5.68u as=0.475p ps=2.88u w=2.5u l=3u
X379 ota_cmfb_top_0.dynamic_pcell_5_0.DRN_NET_CA analog_bus0 ota_cmfb_top_0.dynamic_pcell_5_0.SRC_NET_AB vdd_1v2 sg13_lv_pmos mm_ok=1 ad=0.475p pd=2.88u as=0.475p ps=2.88u w=2.5u l=2u
X380 ota_cmfb_top_0.ota_cmfb_core_push_pull_output_stage_0/dynamic_pcell_4_0.SRC_NET_ML vss_1v2 vss_1v2 vss_1v2 sg13_lv_nmos mm_ok=1 ad=0.133p pd=1.08u as=0.133p ps=1.08u w=0.7u l=0.5u
X381 ota_cmfb_top_0.ota_cmfb_core_push_pull_output_stage_1/dynamic_pcell_4_0.B_DRN ota_cmfb_top_0.dynamic_pcell_5_0.G_DRN vdd_1v2 vdd_1v2 sg13_lv_pmos mm_ok=1 ad=0.475p pd=2.88u as=0.85p ps=5.68u w=2.5u l=3u
X382 vdd_1v2 ota_cmfb_top_0.dynamic_pcell_5_0.H_DRN ota_cmfb_top_0.dynamic_pcell_5_0.SRC_NET_KL vdd_1v2 sg13_lv_pmos mm_ok=1 ad=0.2375p pd=1.63u as=0.2375p ps=1.63u w=1.25u l=5u
X383 w_52782_33612# ota_cmfb_top_0.dynamic_pcell_5_0.DRN_NET_CA w_52782_33612# w_52782_33612# sg13_lv_pmos mm_ok=1 ad=7.31p pd=43.68u as=50.04169p ps=0.10913m w=21.5u l=3.5u
X384 s5_an[1] a_52197_33631# vss_1v2 rhigh l=1u w=0.5u
X385 vss_1v2 ibias0 ibias0 vss_1v2 sg13_lv_nmos mm_ok=1 ad=62.5f pd=0.74u as=62.5f ps=0.74u w=0.25u l=10u
X386 vdd_1v2 vdd_1v2 vdd_1v2 vdd_1v2 sg13_lv_pmos mm_ok=1 ad=95f pd=0.88u as=0 ps=0 w=0.5u l=0.5u
X387 vdd_1v2 vdd_1v2 vdd_1v2 vdd_1v2 sg13_lv_pmos mm_ok=1 ad=0.2375p pd=1.63u as=0 ps=0 w=1.25u l=0.5u
X388 vdd_1v2 vdd_1v2 vdd_1v2 vdd_1v2 sg13_lv_pmos mm_ok=1 ad=0.2375p pd=1.63u as=0 ps=0 w=1.25u l=0.5u
X389 s5_an[2] ota_cmfb_top_0.dynamic_pcell_5_0.DRN_NET_BD vdd_1v2 vdd_1v2 sg13_lv_pmos mm_ok=1 ad=95f pd=0.88u as=95f ps=0.88u w=0.5u l=0.5u
X390 ota_cmfb_top_0.dynamic_pcell_5_0.G_DRN ota_cmfb_top_0.dynamic_pcell_5_0.G_DRN vdd_1v2 vdd_1v2 sg13_lv_pmos mm_ok=1 ad=0.475p pd=2.88u as=0.475p ps=2.88u w=2.5u l=3u
X391 ota_cmfb_top_0.ota_cmfb_core_push_pull_output_stage_0/dynamic_pcell_4_0.DRN_NET_MENX vss_1v2 vss_1v2 vss_1v2 sg13_lv_nmos mm_ok=1 ad=0.133p pd=1.08u as=0.133p ps=1.08u w=0.7u l=3u
X392 ota_cmfb_top_0.ota_cmfb_core_push_pull_output_stage_0/dynamic_pcell_4_0.DRN_NET_J_GATE_EJ ota_cmfb_top_0.ota_cmfb_core_push_pull_output_stage_0/dynamic_pcell_4_0.SRC_NET_QP_GATE_KLQ vss_1v2 vss_1v2 sg13_lv_nmos mm_ok=1 ad=0.133p pd=1.08u as=0.133p ps=1.08u w=0.7u l=3u
X393 ota_cmfb_top_0.dynamic_pcell_5_0.SRC_NET_KL vdd_1v2 vdd_1v2 vdd_1v2 sg13_lv_pmos mm_ok=1 ad=0.475p pd=2.88u as=0.475p ps=2.88u w=2.5u l=0.5u
X394 vdd_1v2 vdd_1v2 vdd_1v2 vdd_1v2 sg13_lv_pmos mm_ok=1 ad=0.475p pd=2.88u as=0 ps=0 w=2.5u l=0.5u
X395 vdd_1v2 vdd_1v2 vdd_1v2 vdd_1v2 sg13_lv_pmos mm_ok=1 ad=0.475p pd=2.88u as=0 ps=0 w=2.5u l=0.5u
X396 ota_cmfb_top_0.ota_cmfb_core_push_pull_output_stage_0/dynamic_pcell_4_0.DRN_NET_CD vdd_1v2 vdd_1v2 vdd_1v2 sg13_lv_pmos mm_ok=1 ad=0.475p pd=2.88u as=0.475p ps=2.88u w=2.5u l=0.5u
X397 vss_1v2 vss_1v2 vss_1v2 vss_1v2 sg13_lv_nmos mm_ok=1 ad=0.238p pd=2.08u as=0 ps=0 w=0.7u l=0.5u
X398 vdd_1v2 vdd_1v2 ota_cmfb_top_0.dynamic_pcell_5_0.DRN_NET_CA vdd_1v2 sg13_lv_pmos mm_ok=1 ad=0.475p pd=2.88u as=0.475p ps=2.88u w=2.5u l=0.5u
X399 a_58402_33917# a_58402_33631# vss_1v2 rhigh l=1u w=0.5u
X400 ota_cmfb_top_0.ota_cmfb_core_push_pull_output_stage_0/dynamic_pcell_4_0.B_DRN ota_cmfb_top_0.dynamic_pcell_5_0.F_DRN vdd_1v2 vdd_1v2 sg13_lv_pmos mm_ok=1 ad=0.475p pd=2.88u as=0.85p ps=5.68u w=2.5u l=3u
X401 vdd_1v2 ota_cmfb_top_0.dynamic_pcell_5_0.G_DRN ota_cmfb_top_0.ota_cmfb_core_push_pull_output_stage_1/dynamic_pcell_4_0.DRN_NET_HI vdd_1v2 sg13_lv_pmos mm_ok=1 ad=0.85p pd=5.68u as=0.475p ps=2.88u w=2.5u l=3u
X402 ota_cmfb_top_0.dynamic_pcell_5_0.H_DRN ibias0 vss_1v2 vss_1v2 sg13_lv_nmos mm_ok=1 ad=62.5f pd=0.74u as=62.5f ps=0.74u w=0.25u l=10u
X403 vdd_1v2 vdd_1v2 vdd_1v2 vdd_1v2 sg13_lv_pmos mm_ok=1 ad=0.85p pd=5.68u as=0 ps=0 w=2.5u l=0.5u
X404 vss_1v2 ota_cmfb_top_0.ota_cmfb_core_push_pull_output_stage_1/dynamic_pcell_4_0.SRC_NET_QP_GATE_KLQ ota_cmfb_top_0.ota_cmfb_core_push_pull_output_stage_1/dynamic_pcell_4_0.DRN_NET_J_GATE_EJ vss_1v2 sg13_lv_nmos mm_ok=1 ad=0.133p pd=1.08u as=0.133p ps=1.08u w=0.7u l=3u
X405 a_49340_27979# a_49076_27693# vss_1v2 rhigh l=1u w=0.5u
X406 vss_1v2 ota_cmfb_top_0.ota_cmfb_core_push_pull_output_stage_1/dynamic_pcell_4_0.SRC_NET_QP_GATE_KLQ ota_cmfb_top_0.ota_cmfb_core_push_pull_output_stage_1/dynamic_pcell_4_0.DRN_NET_J_GATE_EJ vss_1v2 sg13_lv_nmos mm_ok=1 ad=0.133p pd=1.08u as=0.133p ps=1.08u w=0.7u l=3u
X407 vdd_1v2 vdd_1v2 ota_cmfb_top_0.ota_cmfb_core_push_pull_output_stage_1/dynamic_pcell_4_0.SRC_NET_IJ_GATE_DI vdd_1v2 sg13_lv_pmos mm_ok=1 ad=0.475p pd=2.88u as=0.475p ps=2.88u w=2.5u l=0.5u
X408 vss_1v2 ota_cmfb_top_0.ota_cmfb_core_push_pull_output_stage_0/dynamic_pcell_4_0.SRC_NET_QP_GATE_KLQ ota_cmfb_top_0.ota_cmfb_core_push_pull_output_stage_0/dynamic_pcell_4_0.DRN_NET_J_GATE_EJ vss_1v2 sg13_lv_nmos mm_ok=1 ad=0.133p pd=1.08u as=0.133p ps=1.08u w=0.7u l=3u
X409 vdd_1v2 vdd_1v2 vdd_1v2 vdd_1v2 sg13_lv_pmos mm_ok=1 ad=0.475p pd=2.88u as=0 ps=0 w=2.5u l=0.5u
X410 ota_cmfb_top_0.dynamic_pcell_5_0.F_DRN ota_cmfb_top_0.dynamic_pcell_5_0.F_DRN vdd_1v2 vdd_1v2 sg13_lv_pmos mm_ok=1 ad=0.475p pd=2.88u as=0.475p ps=2.88u w=2.5u l=3u
X411 vss_1v2 ibias0 ota_cmfb_top_0.dynamic_pcell_5_0.H_DRN vss_1v2 sg13_lv_nmos mm_ok=1 ad=62.5f pd=0.74u as=62.5f ps=0.74u w=0.25u l=10u
X412 vss_1v2 vss_1v2 vss_1v2 vss_1v2 sg13_lv_nmos mm_ok=1 ad=0.17p pd=1.68u as=0 ps=0 w=0.5u l=0.5u
X413 vss_1v2 vss_1v2 ota_cmfb_top_0.ota_cmfb_core_push_pull_output_stage_0/dynamic_pcell_4_0.SRC_NET_ML vss_1v2 sg13_lv_nmos mm_ok=1 ad=0.133p pd=1.08u as=0.133p ps=1.08u w=0.7u l=0.5u
X414 ota_cmfb_top_0.ota_cmfb_core_push_pull_output_stage_0/dynamic_pcell_4_0.DRN_NET_CD ota_cmfb_top_0.dynamic_pcell_5_0.F_DRN vdd_1v2 vdd_1v2 sg13_lv_pmos mm_ok=1 ad=0.475p pd=2.88u as=0.475p ps=2.88u w=2.5u l=3u
X415 ota_cmfb_top_0.ota_cmfb_core_push_pull_output_stage_0/dynamic_pcell_4_0.DRN_NET_OP_GATE_MP ota_cmfb_top_0.ota_cmfb_core_push_pull_output_stage_0/dynamic_pcell_4_0.B_DRN ota_cmfb_top_0.ota_cmfb_core_push_pull_output_stage_0/dynamic_pcell_4_0.B_DRN vss_1v2 sg13_lv_nmos mm_ok=1 ad=0.133p pd=1.08u as=0.133p ps=1.08u w=0.7u l=3u
X416 ota_cmfb_top_0.dynamic_pcell_5_0.DRN_NET_CA ota_cmfb_top_0.ota_cmfb_core_push_pull_output_stage_1/dynamic_pcell_4_0.SRC_NET_IJ_GATE_DI ota_cmfb_top_0.ota_cmfb_core_push_pull_output_stage_1/dynamic_pcell_4_0.DRN_NET_CD vdd_1v2 sg13_lv_pmos mm_ok=1 ad=0.475p pd=2.88u as=0.475p ps=2.88u w=2.5u l=3u
X417 vss_1v2 ota_cmfb_top_0.ota_cmfb_core_push_pull_output_stage_0/dynamic_pcell_4_0.SRC_NET_QP_GATE_KLQ ota_cmfb_top_0.ota_cmfb_core_push_pull_output_stage_0/dynamic_pcell_4_0.DRN_NET_J_GATE_EJ vss_1v2 sg13_lv_nmos mm_ok=1 ad=0.133p pd=1.08u as=0.133p ps=1.08u w=0.7u l=3u
X418 ota_cmfb_top_0.ota_cmfb_core_push_pull_output_stage_1/dynamic_pcell_4_0.SRC_NET_IJ_GATE_DI ota_cmfb_top_0.ota_cmfb_core_push_pull_output_stage_1/dynamic_pcell_4_0.DRN_NET_J_GATE_EJ ota_cmfb_top_0.ota_cmfb_core_push_pull_output_stage_1/dynamic_pcell_4_0.DRN_NET_J_GATE_EJ vdd_1v2 sg13_lv_pmos mm_ok=1 ad=0.475p pd=2.88u as=0.475p ps=2.88u w=2.5u l=3u
X419 ota_cmfb_top_0.dynamic_pcell_5_0.DRN_NET_BD ota_cmfb_top_0.ota_cmfb_core_push_pull_output_stage_0/dynamic_pcell_4_0.SRC_NET_IJ_GATE_DI ota_cmfb_top_0.ota_cmfb_core_push_pull_output_stage_0/dynamic_pcell_4_0.DRN_NET_CD vdd_1v2 sg13_lv_pmos mm_ok=1 ad=0.475p pd=2.88u as=0.475p ps=2.88u w=2.5u l=3u
X420 vdd_1v2 vdd_1v2 vdd_1v2 vdd_1v2 sg13_lv_pmos mm_ok=1 ad=0.2375p pd=1.63u as=0 ps=0 w=1.25u l=0.5u
X421 vdd_1v2 vdd_1v2 vdd_1v2 vdd_1v2 sg13_lv_pmos mm_ok=1 ad=0.475p pd=2.88u as=0 ps=0 w=2.5u l=0.5u
X422 ota_cmfb_top_0.ota_cmfb_core_push_pull_output_stage_0/dynamic_pcell_4_0.DRN_NET_CD ota_cmfb_top_0.ota_cmfb_core_push_pull_output_stage_0/dynamic_pcell_4_0.SRC_NET_IJ_GATE_DI ota_cmfb_top_0.dynamic_pcell_5_0.DRN_NET_BD vdd_1v2 sg13_lv_pmos mm_ok=1 ad=0.475p pd=2.88u as=0.475p ps=2.88u w=2.5u l=3u
X423 ibias0 ibias0 vss_1v2 vss_1v2 sg13_lv_nmos mm_ok=1 ad=62.5f pd=0.74u as=62.5f ps=0.74u w=0.25u l=10u
X424 a_49076_27418# a_49340_27132# vss_1v2 rhigh l=1u w=0.5u
X425 ota_cmfb_top_0.ota_cmfb_core_push_pull_output_stage_1/dynamic_pcell_4_0.DRN_NET_J_GATE_EJ ota_cmfb_top_0.ota_cmfb_core_push_pull_output_stage_1/dynamic_pcell_4_0.SRC_NET_QP_GATE_KLQ vss_1v2 vss_1v2 sg13_lv_nmos mm_ok=1 ad=0.133p pd=1.08u as=0.133p ps=1.08u w=0.7u l=3u
X426 ota_cmfb_top_0.dynamic_pcell_5_0.SRC_NET_AB ota_cmfb_top_0.dynamic_pcell_5_0.DRN_NET_JL vdd_1v2 vdd_1v2 sg13_lv_pmos mm_ok=1 ad=0.475p pd=2.88u as=0.475p ps=2.88u w=2.5u l=10u
X427 vss_1v2 vss_1v2 ota_cmfb_top_0.ota_cmfb_core_push_pull_output_stage_1/dynamic_pcell_4_0.DRN_NET_OP_GATE_MP vss_1v2 sg13_lv_nmos mm_ok=1 ad=0.133p pd=1.08u as=0.133p ps=1.08u w=0.7u l=0.5u
X428 vdd_1v2 ota_cmfb_top_0.dynamic_pcell_5_0.F_DRN ota_cmfb_top_0.dynamic_pcell_5_0.F_DRN vdd_1v2 sg13_lv_pmos mm_ok=1 ad=0.475p pd=2.88u as=0.475p ps=2.88u w=2.5u l=3u
X429 ota_cmfb_top_0.dynamic_pcell_5_0.DRN_NET_BD ota_cmfb_top_0.ota_cmfb_core_push_pull_output_stage_0/dynamic_pcell_4_0.DRN_NET_J_GATE_EJ ota_cmfb_top_0.ota_cmfb_core_push_pull_output_stage_0/dynamic_pcell_4_0.DRN_NET_MENX vdd_1v2 sg13_lv_pmos mm_ok=1 ad=0.475p pd=2.88u as=0.85p ps=5.68u w=2.5u l=3u
X430 vdd_1v2 ota_cmfb_top_0.dynamic_pcell_5_0.F_DRN ota_cmfb_top_0.dynamic_pcell_5_0.F_DRN vdd_1v2 sg13_lv_pmos mm_ok=1 ad=0.85p pd=5.68u as=0.475p ps=2.88u w=2.5u l=3u
X431 vdd_1v2 ota_cmfb_top_0.dynamic_pcell_5_0.G_DRN ota_cmfb_top_0.ota_cmfb_core_push_pull_output_stage_1/dynamic_pcell_4_0.DRN_NET_CD vdd_1v2 sg13_lv_pmos mm_ok=1 ad=0.475p pd=2.88u as=0.475p ps=2.88u w=2.5u l=3u
X432 ota_cmfb_top_0.dynamic_pcell_5_0.DRN_NET_JL ota_cmfb_top_0.dynamic_pcell_5_0.L_GATE ota_cmfb_top_0.dynamic_pcell_5_0.SRC_NET_KL vdd_1v2 sg13_lv_pmos mm_ok=1 ad=0.475p pd=2.88u as=0.85p ps=5.68u w=2.5u l=2u
X433 ota_cmfb_top_0.ota_cmfb_core_push_pull_output_stage_1/dynamic_pcell_4_0.DRN_NET_J_GATE_EJ ota_cmfb_top_0.ota_cmfb_core_push_pull_output_stage_1/dynamic_pcell_4_0.SRC_NET_QP_GATE_KLQ vss_1v2 vss_1v2 sg13_lv_nmos mm_ok=1 ad=0.133p pd=1.08u as=0.133p ps=1.08u w=0.7u l=3u
X434 vss_1v2 ibias0 ota_cmfb_top_0.dynamic_pcell_5_0.F_DRN vss_1v2 sg13_lv_nmos mm_ok=1 ad=62.5f pd=0.74u as=62.5f ps=0.74u w=0.25u l=10u
X435 s5_an[2] ota_cmfb_top_0.dynamic_pcell_5_0.DRN_NET_BD vdd_1v2 vdd_1v2 sg13_lv_pmos mm_ok=1 ad=95f pd=0.88u as=95f ps=0.88u w=0.5u l=0.5u
X436 ota_cmfb_top_0.ota_cmfb_core_push_pull_output_stage_0/dynamic_pcell_4_0.SRC_NET_IJ_GATE_DI ota_cmfb_top_0.ota_cmfb_core_push_pull_output_stage_0/dynamic_pcell_4_0.SRC_NET_IJ_GATE_DI ota_cmfb_top_0.ota_cmfb_core_push_pull_output_stage_0/dynamic_pcell_4_0.DRN_NET_HI vdd_1v2 sg13_lv_pmos mm_ok=1 ad=0.85p pd=5.68u as=0.475p ps=2.88u w=2.5u l=3u
X437 vdd_1v2 vdd_1v2 vdd_1v2 vdd_1v2 sg13_lv_pmos mm_ok=1 ad=0.2375p pd=1.63u as=0 ps=0 w=1.25u l=0.5u
X438 vdd_1v2 vdd_1v2 vdd_1v2 vdd_1v2 sg13_lv_pmos mm_ok=1 ad=0.475p pd=2.88u as=0 ps=0 w=2.5u l=0.5u
X439 vss_1v2 vss_1v2 vss_1v2 vss_1v2 sg13_lv_nmos mm_ok=1 ad=62.5f pd=0.74u as=0 ps=0 w=0.25u l=0.5u
X440 ota_cmfb_top_0.dynamic_pcell_5_0.SRC_NET_AB ota_cmfb_top_0.dynamic_pcell_5_0.DRN_NET_JL vdd_1v2 vdd_1v2 sg13_lv_pmos mm_ok=1 ad=0.475p pd=2.88u as=0.475p ps=2.88u w=2.5u l=10u
X441 vdd_1v2 ota_cmfb_top_0.dynamic_pcell_5_0.F_DRN ota_cmfb_top_0.dynamic_pcell_5_0.F_DRN vdd_1v2 sg13_lv_pmos mm_ok=1 ad=0.475p pd=2.88u as=0.475p ps=2.88u w=2.5u l=3u
X442 ota_cmfb_top_0.ota_cmfb_core_push_pull_output_stage_0/dynamic_pcell_4_0.SRC_NET_IJ_GATE_DI ota_cmfb_top_0.ota_cmfb_core_push_pull_output_stage_0/dynamic_pcell_4_0.DRN_NET_J_GATE_EJ ota_cmfb_top_0.ota_cmfb_core_push_pull_output_stage_0/dynamic_pcell_4_0.DRN_NET_J_GATE_EJ vdd_1v2 sg13_lv_pmos mm_ok=1 ad=0.475p pd=2.88u as=0.475p ps=2.88u w=2.5u l=3u
X443 vss_1v2 vss_1v2 ota_cmfb_top_0.dynamic_pcell_5_0.F_DRN vss_1v2 sg13_lv_nmos mm_ok=1 ad=62.5f pd=0.74u as=62.5f ps=0.74u w=0.25u l=0.5u
X444 vdd_1v2 vdd_1v2 vdd_1v2 vdd_1v2 sg13_lv_pmos mm_ok=1 ad=0.475p pd=2.88u as=0 ps=0 w=2.5u l=0.5u
X445 vss_1v2 vss_1v2 vss_1v2 vss_1v2 sg13_lv_nmos mm_ok=1 ad=0.238p pd=2.08u as=0 ps=0 w=0.7u l=0.5u
X446 vdd_1v2 ota_cmfb_top_0.dynamic_pcell_5_0.F_DRN ota_cmfb_top_0.ota_cmfb_core_push_pull_output_stage_0/dynamic_pcell_4_0.DRN_NET_CD vdd_1v2 sg13_lv_pmos mm_ok=1 ad=0.475p pd=2.88u as=0.475p ps=2.88u w=2.5u l=3u
X447 vdd_1v2 vdd_1v2 vdd_1v2 vdd_1v2 sg13_lv_pmos mm_ok=1 ad=0.2375p pd=1.63u as=0 ps=0 w=1.25u l=0.5u
X448 ota_cmfb_top_0.ota_cmfb_core_push_pull_output_stage_0/dynamic_pcell_4_0.SRC_NET_ML vss_1v2 vss_1v2 vss_1v2 sg13_lv_nmos mm_ok=1 ad=0.133p pd=1.08u as=0.133p ps=1.08u w=0.7u l=0.5u
X449 vdd_1v2 vdd_1v2 vdd_1v2 vdd_1v2 sg13_lv_pmos mm_ok=1 ad=95f pd=0.88u as=0 ps=0 w=0.5u l=0.5u
X450 ota_cmfb_top_0.dynamic_pcell_5_0.G_DRN ibias0 vss_1v2 vss_1v2 sg13_lv_nmos mm_ok=1 ad=62.5f pd=0.74u as=62.5f ps=0.74u w=0.25u l=10u
X451 ota_cmfb_top_0.dynamic_pcell_5_0.G_DRN ota_cmfb_top_0.dynamic_pcell_5_0.G_DRN vdd_1v2 vdd_1v2 sg13_lv_pmos mm_ok=1 ad=0.475p pd=2.88u as=0.475p ps=2.88u w=2.5u l=3u
X452 vdd_1v2 vdd_1v2 vdd_1v2 vdd_1v2 sg13_lv_pmos mm_ok=1 ad=0.85p pd=5.68u as=0 ps=0 w=2.5u l=0.5u
X453 vss_1v2 vss_1v2 ota_cmfb_top_0.ota_cmfb_core_push_pull_output_stage_1/dynamic_pcell_4_0.DRN_NET_MENX vss_1v2 sg13_lv_nmos mm_ok=1 ad=0.133p pd=1.08u as=0.133p ps=1.08u w=0.7u l=0.5u
X454 ota_cmfb_top_0.ota_cmfb_core_push_pull_output_stage_0/dynamic_pcell_4_0.SRC_NET_IJ_GATE_DI ota_cmfb_top_0.ota_cmfb_core_push_pull_output_stage_0/dynamic_pcell_4_0.SRC_NET_IJ_GATE_DI ota_cmfb_top_0.ota_cmfb_core_push_pull_output_stage_0/dynamic_pcell_4_0.DRN_NET_HI vdd_1v2 sg13_lv_pmos mm_ok=1 ad=0.475p pd=2.88u as=0.475p ps=2.88u w=2.5u l=3u
X455 vdd_1v2 vdd_1v2 vdd_1v2 vdd_1v2 sg13_lv_pmos mm_ok=1 ad=95f pd=0.88u as=0 ps=0 w=0.5u l=0.5u
X456 ota_cmfb_top_0.dynamic_pcell_5_0.G_DRN ota_cmfb_top_0.dynamic_pcell_5_0.G_DRN vdd_1v2 vdd_1v2 sg13_lv_pmos mm_ok=1 ad=0.475p pd=2.88u as=0.475p ps=2.88u w=2.5u l=3u
X457 vdd_1v2 vdd_1v2 ota_cmfb_top_0.dynamic_pcell_5_0.SRC_NET_AB vdd_1v2 sg13_lv_pmos mm_ok=1 ad=0.475p pd=2.88u as=0.475p ps=2.88u w=2.5u l=0.5u
X458 vdd_1v2 ota_cmfb_top_0.dynamic_pcell_5_0.DRN_NET_JL ota_cmfb_top_0.dynamic_pcell_5_0.SRC_NET_AB vdd_1v2 sg13_lv_pmos mm_ok=1 ad=0.475p pd=2.88u as=0.475p ps=2.88u w=2.5u l=10u
X459 vss_1v2 enable ota_cmfb_top_0.EN_INV_1/sg13cmos5l_inv_4_0.Y vss_1v2 sg13_lv_nmos mm_ok=1 ad=0.1406p pd=1.12u as=0.1406p ps=1.12u w=0.74u l=0.13u
X460 vdd_1v2 vdd_1v2 vdd_1v2 vdd_1v2 sg13_lv_pmos mm_ok=1 ad=0.475p pd=2.88u as=0 ps=0 w=2.5u l=0.5u
X461 vdd_1v2 vdd_1v2 vdd_1v2 vdd_1v2 sg13_lv_pmos mm_ok=1 ad=0.17p pd=1.68u as=0 ps=0 w=0.5u l=0.5u
X462 vdd_1v2 vdd_1v2 ota_cmfb_top_0.dynamic_pcell_5_0.DRN_NET_IK_GATE_IJ vdd_1v2 sg13_lv_pmos mm_ok=1 ad=0.475p pd=2.88u as=0.475p ps=2.88u w=2.5u l=0.5u
X463 ota_cmfb_top_0.EN_INV_0/sg13cmos5l_inv_4_0.Y enable vss_1v2 vss_1v2 sg13_lv_nmos mm_ok=1 ad=0.1406p pd=1.12u as=0.1406p ps=1.12u w=0.74u l=0.13u
X464 vdd_1v2 vdd_1v2 vdd_1v2 vdd_1v2 sg13_lv_pmos mm_ok=1 ad=0.475p pd=2.88u as=0 ps=0 w=2.5u l=0.5u
X465 vdd_1v2 vdd_1v2 vdd_1v2 vdd_1v2 sg13_lv_pmos mm_ok=1 ad=0.2375p pd=1.63u as=0 ps=0 w=1.25u l=0.5u
X466 vss_1v2 ota_cmfb_top_0.ota_cmfb_core_push_pull_output_stage_1/dynamic_pcell_4_0.SRC_NET_QP_GATE_KLQ ota_cmfb_top_0.ota_cmfb_core_push_pull_output_stage_1/dynamic_pcell_4_0.SRC_NET_ML vss_1v2 sg13_lv_nmos mm_ok=1 ad=0.133p pd=1.08u as=0.133p ps=1.08u w=0.7u l=3u
X467 vdd_1v2 ota_cmfb_top_0.dynamic_pcell_5_0.F_DRN ota_cmfb_top_0.ota_cmfb_core_push_pull_output_stage_0/dynamic_pcell_4_0.DRN_NET_HI vdd_1v2 sg13_lv_pmos mm_ok=1 ad=0.475p pd=2.88u as=0.475p ps=2.88u w=2.5u l=3u
X468 ota_cmfb_top_0.ota_cmfb_core_push_pull_output_stage_1/dynamic_pcell_4_0.DRN_NET_J_GATE_EJ ota_cmfb_top_0.ota_cmfb_core_push_pull_output_stage_1/dynamic_pcell_4_0.DRN_NET_J_GATE_EJ ota_cmfb_top_0.ota_cmfb_core_push_pull_output_stage_1/dynamic_pcell_4_0.SRC_NET_IJ_GATE_DI vdd_1v2 sg13_lv_pmos mm_ok=1 ad=0.475p pd=2.88u as=0.475p ps=2.88u w=2.5u l=3u
X469 s5_an[1] ota_cmfb_top_0.dynamic_pcell_5_0.DRN_NET_CA vdd_1v2 vdd_1v2 sg13_lv_pmos mm_ok=1 ad=95f pd=0.88u as=95f ps=0.88u w=0.5u l=0.5u
X470 ota_cmfb_top_0.ota_cmfb_core_push_pull_output_stage_0/dynamic_pcell_4_0.DRN_NET_MENX vdd_1v2 vdd_1v2 vdd_1v2 sg13_lv_pmos mm_ok=1 ad=0.475p pd=2.88u as=0.475p ps=2.88u w=2.5u l=0.5u
X471 s5_an[2] ota_cmfb_top_0.dynamic_pcell_5_0.DRN_NET_BD vdd_1v2 vdd_1v2 sg13_lv_pmos mm_ok=1 ad=95f pd=0.88u as=95f ps=0.88u w=0.5u l=0.5u
X472 ota_cmfb_top_0.ota_cmfb_core_push_pull_output_stage_0/dynamic_pcell_4_0.DRN_NET_OP_GATE_MP ota_cmfb_top_0.ota_cmfb_core_push_pull_output_stage_0/dynamic_pcell_4_0.B_DRN ota_cmfb_top_0.ota_cmfb_core_push_pull_output_stage_0/dynamic_pcell_4_0.B_DRN vss_1v2 sg13_lv_nmos mm_ok=1 ad=0.133p pd=1.08u as=0.133p ps=1.08u w=0.7u l=3u
X473 ota_cmfb_top_0.dynamic_pcell_5_0.F_DRN vdd_1v2 vdd_1v2 vdd_1v2 sg13_lv_pmos mm_ok=1 ad=0.475p pd=2.88u as=0.475p ps=2.88u w=2.5u l=0.5u
X474 ota_cmfb_top_0.dynamic_pcell_5_0.DRN_NET_IK_GATE_IJ ota_cmfb_top_0.dynamic_pcell_5_0.DRN_NET_IK_GATE_IJ vss_1v2 vss_1v2 sg13_lv_nmos mm_ok=1 ad=62.5f pd=0.74u as=62.5f ps=0.74u w=0.25u l=10u
X475 ota_cmfb_top_0.dynamic_pcell_5_0.F_DRN ota_cmfb_top_0.dynamic_pcell_5_0.F_DRN vdd_1v2 vdd_1v2 sg13_lv_pmos mm_ok=1 ad=0.475p pd=2.88u as=0.475p ps=2.88u w=2.5u l=3u
X476 vdd_1v2 ota_cmfb_top_0.dynamic_pcell_5_0.DRN_NET_JL ota_cmfb_top_0.dynamic_pcell_5_0.SRC_NET_AB vdd_1v2 sg13_lv_pmos mm_ok=1 ad=0.475p pd=2.88u as=0.475p ps=2.88u w=2.5u l=10u
X477 vdd_1v2 vdd_1v2 vdd_1v2 vdd_1v2 sg13_lv_pmos mm_ok=1 ad=0.85p pd=5.68u as=0 ps=0 w=2.5u l=0.5u
X478 ota_cmfb_top_0.ota_cmfb_core_push_pull_output_stage_1/dynamic_pcell_4_0.DRN_NET_CD ota_cmfb_top_0.ota_cmfb_core_push_pull_output_stage_1/dynamic_pcell_4_0.SRC_NET_IJ_GATE_DI ota_cmfb_top_0.dynamic_pcell_5_0.DRN_NET_CA vdd_1v2 sg13_lv_pmos mm_ok=1 ad=0.475p pd=2.88u as=0.475p ps=2.88u w=2.5u l=3u
X479 vss_1v2 vss_1v2 ota_cmfb_top_0.dynamic_pcell_5_0.H_DRN vss_1v2 sg13_lv_nmos mm_ok=1 ad=62.5f pd=0.74u as=62.5f ps=0.74u w=0.25u l=0.5u
X480 vdd_1v2 vdd_1v2 vdd_1v2 vdd_1v2 sg13_lv_pmos mm_ok=1 ad=0.85p pd=5.68u as=0 ps=0 w=2.5u l=0.5u
X481 vss_1v2 ota_cmfb_top_0.ota_cmfb_core_push_pull_output_stage_1/dynamic_pcell_4_0.SRC_NET_QP_GATE_KLQ ota_cmfb_top_0.ota_cmfb_core_push_pull_output_stage_1/dynamic_pcell_4_0.SRC_NET_ML vss_1v2 sg13_lv_nmos mm_ok=1 ad=0.133p pd=1.08u as=0.133p ps=1.08u w=0.7u l=3u
X482 vss_1v2 vss_1v2 vss_1v2 vss_1v2 sg13_lv_nmos mm_ok=1 ad=0.238p pd=2.08u as=0 ps=0 w=0.7u l=0.5u
X483 vss_1v2 ota_cmfb_top_0.ota_cmfb_core_push_pull_output_stage_0/dynamic_pcell_4_0.SRC_NET_QP_GATE_KLQ ota_cmfb_top_0.ota_cmfb_core_push_pull_output_stage_0/dynamic_pcell_4_0.SRC_NET_ML vss_1v2 sg13_lv_nmos mm_ok=1 ad=0.133p pd=1.08u as=0.133p ps=1.08u w=0.7u l=3u
X484 vdd_1v2 vdd_1v2 vdd_1v2 vdd_1v2 sg13_lv_pmos mm_ok=1 ad=0.475p pd=2.88u as=0 ps=0 w=2.5u l=0.5u
X485 vdd_1v2 ota_cmfb_top_0.dynamic_pcell_5_0.G_DRN ota_cmfb_top_0.ota_cmfb_core_push_pull_output_stage_1/dynamic_pcell_4_0.DRN_NET_CD vdd_1v2 sg13_lv_pmos mm_ok=1 ad=0.475p pd=2.88u as=0.475p ps=2.88u w=2.5u l=3u
X486 vdd_1v2 vdd_1v2 vdd_1v2 vdd_1v2 sg13_lv_pmos mm_ok=1 ad=0.2375p pd=1.63u as=0 ps=0 w=1.25u l=0.5u
X487 vdd_1v2 vdd_1v2 vdd_1v2 vdd_1v2 sg13_lv_pmos mm_ok=1 ad=0.475p pd=2.88u as=0 ps=0 w=2.5u l=0.5u
X488 vss_1v2 vss_1v2 ota_cmfb_top_0.ota_cmfb_core_push_pull_output_stage_1/dynamic_pcell_4_0.DRN_NET_OP_GATE_MP vss_1v2 sg13_lv_nmos mm_ok=1 ad=0.133p pd=1.08u as=0.133p ps=1.08u w=0.7u l=0.5u
X489 ota_cmfb_top_0.ota_cmfb_core_push_pull_output_stage_0/dynamic_pcell_4_0.DRN_NET_OP_GATE_MP ota_cmfb_top_0.ota_cmfb_core_push_pull_output_stage_0/dynamic_pcell_4_0.DRN_NET_OP_GATE_MP ota_cmfb_top_0.ota_cmfb_core_push_pull_output_stage_0/dynamic_pcell_4_0.SRC_NET_QP_GATE_KLQ vss_1v2 sg13_lv_nmos mm_ok=1 ad=0.133p pd=1.08u as=0.133p ps=1.08u w=0.7u l=3u
X490 ota_cmfb_top_0.ota_cmfb_core_push_pull_output_stage_0/dynamic_pcell_4_0.DRN_NET_J_GATE_EJ ota_cmfb_top_0.ota_cmfb_core_push_pull_output_stage_0/dynamic_pcell_4_0.DRN_NET_J_GATE_EJ ota_cmfb_top_0.ota_cmfb_core_push_pull_output_stage_0/dynamic_pcell_4_0.SRC_NET_IJ_GATE_DI vdd_1v2 sg13_lv_pmos mm_ok=1 ad=0.475p pd=2.88u as=0.475p ps=2.88u w=2.5u l=3u
X491 ota_cmfb_top_0.dynamic_pcell_5_0.DRN_NET_BD analog_bus1 ota_cmfb_top_0.dynamic_pcell_5_0.SRC_NET_AB vdd_1v2 sg13_lv_pmos mm_ok=1 ad=0.475p pd=2.88u as=0.475p ps=2.88u w=2.5u l=2u
X492 ota_cmfb_top_0.dynamic_pcell_5_0.SRC_NET_AB analog_bus1 ota_cmfb_top_0.dynamic_pcell_5_0.DRN_NET_BD vdd_1v2 sg13_lv_pmos mm_ok=1 ad=0.475p pd=2.88u as=0.475p ps=2.88u w=2.5u l=2u
X493 s5_an[1] ota_cmfb_top_0.dynamic_pcell_5_0.DRN_NET_CA vdd_1v2 vdd_1v2 sg13_lv_pmos mm_ok=1 ad=95f pd=0.88u as=0.17p ps=1.68u w=0.5u l=0.5u
X494 vss_1v2 vss_1v2 ota_cmfb_top_0.ota_cmfb_core_push_pull_output_stage_0/dynamic_pcell_4_0.SRC_NET_ML vss_1v2 sg13_lv_nmos mm_ok=1 ad=0.133p pd=1.08u as=0.133p ps=1.08u w=0.7u l=0.5u
X495 vss_1v2 vss_1v2 vss_1v2 vss_1v2 sg13_lv_nmos mm_ok=1 ad=0.238p pd=2.08u as=0 ps=0 w=0.7u l=0.5u
X496 vdd_1v2 vdd_1v2 vdd_1v2 vdd_1v2 sg13_lv_pmos mm_ok=1 ad=0.85p pd=5.68u as=0 ps=0 w=2.5u l=0.5u
X497 ota_cmfb_top_0.ota_cmfb_core_push_pull_output_stage_1/dynamic_pcell_4_0.SRC_NET_IJ_GATE_DI ota_cmfb_top_0.ota_cmfb_core_push_pull_output_stage_1/dynamic_pcell_4_0.SRC_NET_IJ_GATE_DI ota_cmfb_top_0.ota_cmfb_core_push_pull_output_stage_1/dynamic_pcell_4_0.DRN_NET_HI vdd_1v2 sg13_lv_pmos mm_ok=1 ad=0.85p pd=5.68u as=0.475p ps=2.88u w=2.5u l=3u
X498 ota_cmfb_top_0.ota_cmfb_core_push_pull_output_stage_1/dynamic_pcell_4_0.DRN_NET_HI ota_cmfb_top_0.dynamic_pcell_5_0.G_DRN vdd_1v2 vdd_1v2 sg13_lv_pmos mm_ok=1 ad=0.475p pd=2.88u as=0.85p ps=5.68u w=2.5u l=3u
X499 vss_1v2 ota_cmfb_top_0.dynamic_pcell_5_0.DRN_NET_IK_GATE_IJ ota_cmfb_top_0.dynamic_pcell_5_0.DRN_NET_JL vss_1v2 sg13_lv_nmos mm_ok=1 ad=62.5f pd=0.74u as=62.5f ps=0.74u w=0.25u l=10u
X500 a_50924_27979# a_50660_27693# vss_1v2 rhigh l=1u w=0.5u
X501 vdd_1v2 vdd_1v2 vdd_1v2 vdd_1v2 sg13_lv_pmos mm_ok=1 ad=0.2375p pd=1.63u as=0 ps=0 w=1.25u l=0.5u
X502 a_58666_33917# a_58402_33631# vss_1v2 rhigh l=1u w=0.5u
X503 vdd_1v2 vdd_1v2 vdd_1v2 vdd_1v2 sg13_lv_pmos mm_ok=1 ad=0.2375p pd=1.63u as=0 ps=0 w=1.25u l=0.5u
X504 ota_cmfb_top_0.ota_cmfb_core_push_pull_output_stage_1/dynamic_pcell_4_0.B_DRN ota_cmfb_top_0.ota_cmfb_core_push_pull_output_stage_1/dynamic_pcell_4_0.B_DRN ota_cmfb_top_0.ota_cmfb_core_push_pull_output_stage_1/dynamic_pcell_4_0.DRN_NET_OP_GATE_MP vss_1v2 sg13_lv_nmos mm_ok=1 ad=0.133p pd=1.08u as=0.133p ps=1.08u w=0.7u l=3u
X505 vdd_1v2 vdd_1v2 vdd_1v2 vdd_1v2 sg13_lv_pmos mm_ok=1 ad=95f pd=0.88u as=0 ps=0 w=0.5u l=0.5u
X506 vdd_1v2 ota_cmfb_top_0.dynamic_pcell_5_0.G_DRN ota_cmfb_top_0.dynamic_pcell_5_0.G_DRN vdd_1v2 sg13_lv_pmos mm_ok=1 ad=0.475p pd=2.88u as=0.475p ps=2.88u w=2.5u l=3u
X507 ota_cmfb_top_0.dynamic_pcell_5_0.DRN_NET_BD ibias0 vss_1v2 vss_1v2 sg13_lv_nmos mm_ok=1 ad=62.5f pd=0.74u as=62.5f ps=0.74u w=0.25u l=10u
X508 vdd_1v2 ota_cmfb_top_0.dynamic_pcell_5_0.G_DRN ota_cmfb_top_0.dynamic_pcell_5_0.G_DRN vdd_1v2 sg13_lv_pmos mm_ok=1 ad=0.475p pd=2.88u as=0.475p ps=2.88u w=2.5u l=3u
X509 vdd_1v2 ota_cmfb_top_0.dynamic_pcell_5_0.H_DRN ota_cmfb_top_0.dynamic_pcell_5_0.H_DRN vdd_1v2 sg13_lv_pmos mm_ok=1 ad=0.2375p pd=1.63u as=0.2375p ps=1.63u w=1.25u l=5u
X510 vdd_1v2 vdd_1v2 vdd_1v2 vdd_1v2 sg13_lv_pmos mm_ok=1 ad=0.475p pd=2.88u as=0 ps=0 w=2.5u l=0.5u
X511 vdd_1v2 vdd_1v2 vdd_1v2 vdd_1v2 sg13_lv_pmos mm_ok=1 ad=95f pd=0.88u as=0 ps=0 w=0.5u l=0.5u
X512 ota_cmfb_top_0.ota_cmfb_core_push_pull_output_stage_0/dynamic_pcell_4_0.DRN_NET_MENX vss_1v2 vss_1v2 vss_1v2 sg13_lv_nmos mm_ok=1 ad=0.133p pd=1.08u as=0.133p ps=1.08u w=0.7u l=3u
X513 ota_cmfb_top_0.ota_cmfb_core_push_pull_output_stage_1/dynamic_pcell_4_0.SRC_NET_ML ota_cmfb_top_0.ota_cmfb_core_push_pull_output_stage_1/dynamic_pcell_4_0.DRN_NET_OP_GATE_MP ota_cmfb_top_0.ota_cmfb_core_push_pull_output_stage_1/dynamic_pcell_4_0.DRN_NET_MENX vss_1v2 sg13_lv_nmos mm_ok=1 ad=0.133p pd=1.08u as=0.133p ps=1.08u w=0.7u l=3u
X514 vdd_1v2 ota_cmfb_top_0.dynamic_pcell_5_0.F_DRN ota_cmfb_top_0.dynamic_pcell_5_0.F_DRN vdd_1v2 sg13_lv_pmos mm_ok=1 ad=0.475p pd=2.88u as=0.475p ps=2.88u w=2.5u l=3u
X515 ota_cmfb_top_0.dynamic_pcell_5_0.DRN_NET_CA ibias0 vss_1v2 vss_1v2 sg13_lv_nmos mm_ok=1 ad=62.5f pd=0.74u as=62.5f ps=0.74u w=0.25u l=10u
X516 ota_cmfb_top_0.ota_cmfb_core_push_pull_output_stage_1/dynamic_pcell_4_0.SRC_NET_ML ota_cmfb_top_0.ota_cmfb_core_push_pull_output_stage_1/dynamic_pcell_4_0.DRN_NET_OP_GATE_MP ota_cmfb_top_0.ota_cmfb_core_push_pull_output_stage_1/dynamic_pcell_4_0.DRN_NET_MENX vss_1v2 sg13_lv_nmos mm_ok=1 ad=0.133p pd=1.08u as=0.133p ps=1.08u w=0.7u l=3u
X517 ota_cmfb_top_0.ota_cmfb_core_push_pull_output_stage_0/dynamic_pcell_4_0.SRC_NET_IJ_GATE_DI vdd_1v2 vdd_1v2 vdd_1v2 sg13_lv_pmos mm_ok=1 ad=0.475p pd=2.88u as=0.475p ps=2.88u w=2.5u l=0.5u
X518 vdd_1v2 vdd_1v2 vdd_1v2 vdd_1v2 sg13_lv_pmos mm_ok=1 ad=0.2375p pd=1.63u as=0 ps=0 w=1.25u l=0.5u
X519 a_52197_34440# w_52782_33612# vss_1v2 rhigh l=1u w=0.5u
X520 vss_1v2 vss_1v2 ibias0 vss_1v2 sg13_lv_nmos mm_ok=1 ad=62.5f pd=0.74u as=62.5f ps=0.74u w=0.25u l=0.5u
X521 ota_cmfb_top_0.EN_INV_1/sg13cmos5l_inv_4_0.Y enable vdd_1v2 vdd_1v2 sg13_lv_pmos mm_ok=1 ad=0.2128p pd=1.5u as=0.2128p ps=1.5u w=1.12u l=0.13u
C0 analog_bus1 ota_cmfb_top_0.dynamic_pcell_5_0.SRC_NET_AB 2.73939f
C1 ota_cmfb_top_0.ota_cmfb_core_push_pull_output_stage_1/dynamic_pcell_4_0.DRN_NET_HI ota_cmfb_top_0.dynamic_pcell_5_0.G_DRN 4.57567f
C2 ota_cmfb_top_0.dynamic_pcell_5_0.SRC_NET_AB ota_cmfb_top_0.dynamic_pcell_5_0.DRN_NET_CA 0.73788f
C3 ota_cmfb_top_0.ota_cmfb_core_push_pull_output_stage_0/dynamic_pcell_4_0.SRC_NET_IJ_GATE_DI ota_cmfb_top_0.dynamic_pcell_5_0.F_DRN 2.33609f
C4 s5_an[2] s5_an[1] 0.25556f
C5 vdd_1v2 a_51669_33917# 0.04344f
C6 a_49340_27779# a_49604_27779# 0.02325f
C7 s5_an[1] ibias0 0.01364f
C8 ota_cmfb_top_0.dynamic_pcell_5_0.DRN_NET_JL a_49340_27979# 0.0104f
C9 vdd_1v2 ota_cmfb_top_0.ota_cmfb_core_push_pull_output_stage_0/dynamic_pcell_4_0.DRN_NET_J_GATE_EJ 13.6843f
C10 s5_an[1] a_52197_34440# 0.14483f
C11 ota_cmfb_top_0.dynamic_pcell_5_0.DRN_NET_BD ota_cmfb_top_0.dynamic_pcell_5_0.DRN_NET_IK_GATE_IJ 1.09377f
C12 a_50396_27132# a_50660_27218# 0.01257f
C13 ota_cmfb_top_0.ota_cmfb_core_push_pull_output_stage_1/dynamic_pcell_4_0.DRN_NET_MENX ota_cmfb_top_0.ota_cmfb_core_push_pull_output_stage_1/dynamic_pcell_4_0.DRN_NET_OP_GATE_MP 5.62824f
C14 a_52197_33631# a_52461_33717# 0.01257f
C15 ibias0 ota_cmfb_top_0.EN_INV_1/sg13cmos5l_inv_4_0.Y 0.01652f
C16 a_49340_27132# a_48812_27132# 0.01672f
C17 vdd_1v2 a_49868_27979# 0.05377f
C18 w_52782_33612# a_52197_34440# 0.01802f
C19 ota_cmfb_top_0.ota_cmfb_core_push_pull_output_stage_1/dynamic_pcell_4_0.DRN_NET_CD ota_cmfb_top_0.ota_cmfb_core_push_pull_output_stage_1/dynamic_pcell_4_0.DRN_NET_HI 0.04326f
C20 a_50924_27779# a_51188_27779# 0.02325f
C21 vdd_1v2 ota_cmfb_top_0.dynamic_pcell_5_0.DRN_NET_IK_GATE_IJ 2.48558f
C22 a_50396_27218# a_50132_27218# 0.02325f
C23 a_49868_27979# a_49868_27779# 0.01257f
C24 a_50660_27418# a_50660_27218# 0.01257f
C25 ota_cmfb_top_0.dynamic_pcell_5_0.DRN_NET_CA a_52461_34240# 0.01075f
C26 ota_cmfb_top_0.dynamic_pcell_5_0.L_GATE a_49076_27693# 0.01688f
C27 vdd_1v2 a_51669_34440# 0.03413f
C28 a_50132_27418# a_50660_27418# 0.01672f
C29 ibias0 enable 4.87117f
C30 a_49604_27779# a_49604_27693# 0.01257f
C31 s5_an[0] ota_cmfb_top_0.dynamic_pcell_5_0.SRC_NET_AB 1.9876f
C32 a_58666_34154# a_58402_33917# 0.0169f
C33 slot5_wrapper_0.dig_in[1] slot5_wrapper_0.dig_in[0] 0.23029f
C34 a_51669_34240# a_51669_33917# 0.01218f
C35 ota_cmfb_top_0.dynamic_pcell_5_0.SRC_NET_AB ota_cmfb_top_0.dynamic_pcell_5_0.SRC_NET_KL 1.33403f
C36 ota_cmfb_top_0.ota_cmfb_core_push_pull_output_stage_0/dynamic_pcell_4_0.SRC_NET_ML ota_cmfb_top_0.dynamic_pcell_5_0.F_DRN 0.53557f
C37 analog_bus1 m3_0_22251# 0.16363f
C38 s5_an[1] ota_cmfb_top_0.ota_cmfb_core_push_pull_output_stage_0/dynamic_pcell_4_0.SRC_NET_IJ_GATE_DI 0.06092f
C39 a_50924_27218# a_50660_27418# 0.01257f
C40 s5_an[2] a_51188_27779# 0.02043f
C41 a_50924_27779# a_50660_27779# 0.02325f
C42 ota_cmfb_top_0.dynamic_pcell_5_0.L_GATE ota_cmfb_top_0.dynamic_pcell_5_0.SRC_NET_AB 0.17789f
C43 ota_cmfb_top_0.dynamic_pcell_5_0.SRC_NET_AB ota_cmfb_top_0.dynamic_pcell_5_0.H_DRN 0.1765f
C44 ota_cmfb_top_0.ota_cmfb_core_push_pull_output_stage_1/dynamic_pcell_4_0.DRN_NET_J_GATE_EJ s5_an[2] 4.27287f
C45 ota_cmfb_top_0.dynamic_pcell_5_0.DRN_NET_BD s5_an[2] 1.1176f
C46 a_49340_27218# a_49340_27132# 0.01257f
C47 ota_cmfb_top_0.dynamic_pcell_5_0.DRN_NET_BD ibias0 12.3067f
C48 m3_0_20487# slot5_wrapper_0.ibias1 0.15943f
C49 a_50660_27693# a_50924_27779# 0.01257f
C50 a_50660_27693# a_50660_27418# 0.0607f
C51 ota_cmfb_top_0.ota_cmfb_core_push_pull_output_stage_0/dynamic_pcell_4_0.DRN_NET_MENX ota_cmfb_top_0.dynamic_pcell_5_0.F_DRN 0.14511f
C52 a_58666_34240# a_58930_34240# 0.02325f
C53 w_59515_33612# a_58930_33631# 0.01194f
C54 a_48812_27218# a_48812_27132# 0.01257f
C55 ibias0 m3_0_19899# 0.15943f
C56 slot5_wrapper_0.dig_in[21] slot5_wrapper_0.dig_in[22] 0.23029f
C57 vdd_1v2 s5_an[2] 11.7829f
C58 ota_cmfb_top_0.ota_cmfb_core_push_pull_output_stage_1/dynamic_pcell_4_0.B_DRN s5_an[2] 0.24647f
C59 ota_cmfb_top_0.ota_cmfb_core_push_pull_output_stage_0/dynamic_pcell_4_0.DRN_NET_CD ota_cmfb_top_0.ota_cmfb_core_push_pull_output_stage_0/dynamic_pcell_4_0.B_DRN 0.03703f
C60 s5_an[2] a_58666_34240# 0.01404f
C61 vdd_1v2 ibias0 8.86967f
C62 s5_an[1] a_51933_33917# 0.129f
C63 ota_cmfb_top_0.dynamic_pcell_5_0.DRN_NET_JL ota_cmfb_top_0.dynamic_pcell_5_0.F_DRN 0.05479f
C64 ota_cmfb_top_0.dynamic_pcell_5_0.DRN_NET_BD a_59194_34240# 0.01075f
C65 a_51669_34240# a_51669_34440# 0.01257f
C66 vdd_1v2 a_50396_27979# 0.06157f
C67 ota_cmfb_top_0.dynamic_pcell_5_0.DRN_NET_CA ota_cmfb_top_0.ota_cmfb_core_push_pull_output_stage_1/dynamic_pcell_4_0.DRN_NET_OP_GATE_MP 0.04023f
C68 ota_cmfb_top_0.ota_cmfb_core_push_pull_output_stage_1/dynamic_pcell_4_0.DRN_NET_J_GATE_EJ ota_cmfb_top_0.ota_cmfb_core_push_pull_output_stage_1/dynamic_pcell_4_0.DRN_NET_HI 2.92898f
C69 ota_cmfb_top_0.dynamic_pcell_5_0.DRN_NET_BD ota_cmfb_top_0.ota_cmfb_core_push_pull_output_stage_1/dynamic_pcell_4_0.DRN_NET_HI 0.23522f
C70 s5_an[2] a_58402_34440# 0.04206f
C71 a_50396_27779# a_50660_27779# 0.02325f
C72 analog_bus0 m3_0_22839# 0.15943f
C73 a_58402_33917# a_58666_33917# 0.01702f
C74 a_50132_27693# a_50132_27779# 0.01257f
C75 ota_cmfb_top_0.dynamic_pcell_5_0.DRN_NET_BD analog_bus0 4.17934f
C76 ota_cmfb_top_0.ota_cmfb_core_push_pull_output_stage_0/dynamic_pcell_4_0.DRN_NET_HI ota_cmfb_top_0.ota_cmfb_core_push_pull_output_stage_0/dynamic_pcell_4_0.DRN_NET_CD 0.04429f
C77 a_52197_33631# a_52197_33717# 0.01257f
C78 a_50660_27693# s5_an[2] 0.024f
C79 a_58666_33717# a_58666_33917# 0.01257f
C80 a_48812_27218# a_49076_27218# 0.02325f
C81 a_50396_27979# a_50660_27779# 0.01257f
C82 slot5_wrapper_0.dig_out[3] slot5_wrapper_0.dig_out[2] 0.23029f
C83 ota_cmfb_top_0.ota_cmfb_core_push_pull_output_stage_0/dynamic_pcell_4_0.SRC_NET_QP_GATE_KLQ ota_cmfb_top_0.ota_cmfb_core_push_pull_output_stage_0/dynamic_pcell_4_0.B_DRN 0.76289f
C84 ota_cmfb_top_0.ota_cmfb_core_push_pull_output_stage_1/dynamic_pcell_4_0.B_DRN ota_cmfb_top_0.ota_cmfb_core_push_pull_output_stage_1/dynamic_pcell_4_0.DRN_NET_HI 0.03502f
C85 vdd_1v2 ota_cmfb_top_0.ota_cmfb_core_push_pull_output_stage_1/dynamic_pcell_4_0.DRN_NET_HI 2.76149f
C86 s5_an[1] ota_cmfb_top_0.ota_cmfb_core_push_pull_output_stage_0/dynamic_pcell_4_0.SRC_NET_ML 0.0186f
C87 a_50396_27218# a_50396_27132# 0.01257f
C88 a_45783_27500# enable 0.03634f
C89 ota_cmfb_top_0.dynamic_pcell_5_0.DRN_NET_JL ota_cmfb_top_0.dynamic_pcell_5_0.G_DRN 0.05679f
C90 a_52197_34440# a_52197_34240# 0.01257f
C91 slot5_wrapper_0.vss_3v3 m3_0_22839# 0.05f
C92 vdd_1v2 analog_bus0 20.4212f
C93 ota_cmfb_top_0.dynamic_pcell_5_0.DRN_NET_BD ota_cmfb_top_0.ota_cmfb_core_push_pull_output_stage_0/dynamic_pcell_4_0.SRC_NET_IJ_GATE_DI 3.99589f
C94 slot5_wrapper_0.dig_in[11] slot5_wrapper_0.dig_in[12] 0.23029f
C95 ota_cmfb_top_0.dynamic_pcell_5_0.DRN_NET_IK_GATE_IJ ota_cmfb_top_0.EN_INV_0/sg13cmos5l_inv_4_0.Y 0.01859f
C96 s5_an[2] ota_cmfb_top_0.ota_cmfb_core_push_pull_output_stage_1/dynamic_pcell_4_0.DRN_NET_MENX 0.08199f
C97 a_49076_27779# a_48812_27979# 0.01257f
C98 ota_cmfb_top_0.ota_cmfb_core_push_pull_output_stage_1/dynamic_pcell_4_0.DRN_NET_OP_GATE_MP ota_cmfb_top_0.ota_cmfb_core_push_pull_output_stage_1/dynamic_pcell_4_0.SRC_NET_QP_GATE_KLQ 6.16765f
C99 m3_0_20487# slot5_wrapper_0.analog_bus3 0.15943f
C100 s5_an[1] ota_cmfb_top_0.ota_cmfb_core_push_pull_output_stage_0/dynamic_pcell_4_0.DRN_NET_MENX 0.05406f
C101 vdd_1v2 ota_cmfb_top_0.ota_cmfb_core_push_pull_output_stage_0/dynamic_pcell_4_0.SRC_NET_IJ_GATE_DI 17.5603f
C102 s5_an[2] a_58402_33631# 0.04349f
C103 ota_cmfb_top_0.ota_cmfb_core_push_pull_output_stage_1/dynamic_pcell_4_0.DRN_NET_OP_GATE_MP ota_cmfb_top_0.ota_cmfb_core_push_pull_output_stage_1/dynamic_pcell_4_0.SRC_NET_ML 2.78684f
C104 a_49076_27418# a_49076_27218# 0.01257f
C105 slot5_wrapper_0.dig_out[1] slot5_wrapper_0.dig_out[0] 0.23029f
C106 analog_bus1 ota_cmfb_top_0.dynamic_pcell_5_0.DRN_NET_IK_GATE_IJ 1.74332f
C107 ota_cmfb_top_0.dynamic_pcell_5_0.DRN_NET_IK_GATE_IJ ota_cmfb_top_0.dynamic_pcell_5_0.DRN_NET_CA 1.11652f
C108 a_58666_33717# a_58930_33717# 0.02325f
C109 ota_cmfb_top_0.ota_cmfb_core_push_pull_output_stage_0/dynamic_pcell_4_0.DRN_NET_CD ota_cmfb_top_0.ota_cmfb_core_push_pull_output_stage_0/dynamic_pcell_4_0.DRN_NET_J_GATE_EJ 0.11586f
C110 ota_cmfb_top_0.ota_cmfb_core_push_pull_output_stage_1/dynamic_pcell_4_0.DRN_NET_HI ota_cmfb_top_0.ota_cmfb_core_push_pull_output_stage_1/dynamic_pcell_4_0.DRN_NET_MENX 0.09335f
C111 ota_cmfb_top_0.ota_cmfb_core_push_pull_output_stage_0/dynamic_pcell_4_0.DRN_NET_OP_GATE_MP ota_cmfb_top_0.ota_cmfb_core_push_pull_output_stage_0/dynamic_pcell_4_0.SRC_NET_QP_GATE_KLQ 6.16765f
C112 ota_cmfb_top_0.dynamic_pcell_5_0.DRN_NET_JL ota_cmfb_top_0.EN_INV_1/sg13cmos5l_inv_4_0.Y 0.02777f
C113 slot5_wrapper_0.vbias m3_0_19311# 0.15943f
C114 slot5_wrapper_0.dig_in[11] slot5_wrapper_0.dig_in[10] 0.23029f
C115 a_49340_27218# a_49076_27418# 0.01257f
C116 a_58666_34240# a_58402_34240# 0.02325f
C117 vdd_1v2 a_48812_27979# 0.05592f
C118 ota_cmfb_top_0.dynamic_pcell_5_0.F_DRN ota_cmfb_top_0.dynamic_pcell_5_0.G_DRN 2.30424f
C119 s5_an[2] a_58402_33917# 0.01687f
C120 slot5_wrapper_0.dig_in[5] slot5_wrapper_0.dig_in[6] 0.23029f
C121 ota_cmfb_top_0.dynamic_pcell_5_0.DRN_NET_BD ota_cmfb_top_0.ota_cmfb_core_push_pull_output_stage_0/dynamic_pcell_4_0.SRC_NET_ML 0.02335f
C122 a_58402_34440# a_58402_34240# 0.01257f
C123 slot5_wrapper_0.dig_in[13] slot5_wrapper_0.dig_in[12] 0.23029f
C124 a_58666_33717# s5_an[2] 0.01404f
C125 ota_cmfb_top_0.ota_cmfb_core_push_pull_output_stage_0/dynamic_pcell_4_0.SRC_NET_QP_GATE_KLQ ota_cmfb_top_0.ota_cmfb_core_push_pull_output_stage_0/dynamic_pcell_4_0.DRN_NET_J_GATE_EJ 6.34946f
C126 ota_cmfb_top_0.dynamic_pcell_5_0.DRN_NET_JL enable 0.04327f
C127 slot5_wrapper_0.dig_in[15] slot5_wrapper_0.dig_in[14] 0.23029f
C128 s5_an[1] a_51933_34240# 0.01404f
C129 vdd_1v2 a_49340_27979# 0.05377f
C130 a_49604_27218# a_49868_27218# 0.02325f
C131 a_51933_33717# a_52197_33717# 0.02325f
C132 a_58930_34440# a_58930_34240# 0.01257f
C133 s5_an[0] ota_cmfb_top_0.dynamic_pcell_5_0.DRN_NET_IK_GATE_IJ 4.18002f
C134 s5_an[1] ota_cmfb_top_0.dynamic_pcell_5_0.F_DRN 0.49837f
C135 ota_cmfb_top_0.dynamic_pcell_5_0.DRN_NET_BD ota_cmfb_top_0.ota_cmfb_core_push_pull_output_stage_0/dynamic_pcell_4_0.DRN_NET_MENX 4.81779f
C136 w_59515_33612# a_58666_34154# 0.01701f
C137 s5_an[2] a_58930_34440# 0.13315f
C138 ota_cmfb_top_0.dynamic_pcell_5_0.L_GATE a_48812_27132# 0.01108f
C139 ota_cmfb_top_0.dynamic_pcell_5_0.DRN_NET_IK_GATE_IJ ota_cmfb_top_0.dynamic_pcell_5_0.SRC_NET_KL 1.68329f
C140 s5_an[2] ota_cmfb_top_0.dynamic_pcell_5_0.DRN_NET_CA 0.11596f
C141 a_51933_34154# a_51669_33917# 0.0169f
C142 ibias0 ota_cmfb_top_0.dynamic_pcell_5_0.DRN_NET_CA 11.487f
C143 ota_cmfb_top_0.ota_cmfb_core_push_pull_output_stage_1/dynamic_pcell_4_0.DRN_NET_CD ota_cmfb_top_0.dynamic_pcell_5_0.G_DRN 3.4607f
C144 ota_cmfb_top_0.dynamic_pcell_5_0.DRN_NET_BD ota_cmfb_top_0.dynamic_pcell_5_0.DRN_NET_JL 0.19504f
C145 vdd_1v2 ota_cmfb_top_0.ota_cmfb_core_push_pull_output_stage_0/dynamic_pcell_4_0.DRN_NET_MENX 3.20006f
C146 ota_cmfb_top_0.dynamic_pcell_5_0.L_GATE ota_cmfb_top_0.dynamic_pcell_5_0.DRN_NET_IK_GATE_IJ 0.61696f
C147 ota_cmfb_top_0.dynamic_pcell_5_0.H_DRN ota_cmfb_top_0.dynamic_pcell_5_0.DRN_NET_IK_GATE_IJ 0.18226f
C148 a_48812_27779# ota_cmfb_top_0.dynamic_pcell_5_0.L_GATE 0.0169f
C149 a_49340_27979# a_49340_27779# 0.01257f
C150 a_50132_27693# a_50396_27779# 0.01257f
C151 s5_an[1] ota_cmfb_top_0.dynamic_pcell_5_0.G_DRN 0.77444f
C152 vdd_1v2 ota_cmfb_top_0.dynamic_pcell_5_0.DRN_NET_JL 48.1771f
C153 a_59194_34240# a_58930_34440# 0.01257f
C154 s5_an[2] ota_cmfb_top_0.ota_cmfb_core_push_pull_output_stage_0/dynamic_pcell_4_0.DRN_NET_CD 0.13443f
C155 ota_cmfb_top_0.ota_cmfb_core_push_pull_output_stage_1/dynamic_pcell_4_0.DRN_NET_HI ota_cmfb_top_0.dynamic_pcell_5_0.DRN_NET_CA 0.15912f
C156 analog_bus1 analog_bus0 8.36971f
C157 analog_bus0 ota_cmfb_top_0.dynamic_pcell_5_0.DRN_NET_CA 8.78099f
C158 slot5_wrapper_0.dig_in[3] slot5_wrapper_0.dig_in[2] 0.23029f
C159 ota_cmfb_top_0.ota_cmfb_core_push_pull_output_stage_1/dynamic_pcell_4_0.DRN_NET_CD s5_an[1] 0.15155f
C160 a_49604_27418# a_50132_27418# 0.01672f
C161 slot5_wrapper_0.dig_in[10] slot5_wrapper_0.dig_in[9] 0.23029f
C162 a_58402_34240# a_58402_33917# 0.01218f
C163 s5_an[2] ota_cmfb_top_0.ota_cmfb_core_push_pull_output_stage_0/dynamic_pcell_4_0.SRC_NET_QP_GATE_KLQ 0.02992f
C164 a_49340_27218# a_49604_27218# 0.02325f
C165 vdd_1v2 a_51669_33717# 0.01529f
C166 slot5_wrapper_0.vss_3v3 analog_bus1 0.01551f
C167 s5_an[0] ibias0 1.16295f
C168 ota_cmfb_top_0.ota_cmfb_core_push_pull_output_stage_1/dynamic_pcell_4_0.DRN_NET_J_GATE_EJ ota_cmfb_top_0.dynamic_pcell_5_0.F_DRN 0.04499f
C169 ota_cmfb_top_0.dynamic_pcell_5_0.DRN_NET_BD ota_cmfb_top_0.dynamic_pcell_5_0.F_DRN 10.1237f
C170 w_52782_33612# s5_an[1] 0.19983f
C171 ota_cmfb_top_0.dynamic_pcell_5_0.L_GATE ibias0 0.16054f
C172 ota_cmfb_top_0.dynamic_pcell_5_0.H_DRN ibias0 2.79123f
C173 slot5_wrapper_0.dig_in[13] slot5_wrapper_0.dig_in[14] 0.23029f
C174 vdd_1v2 ota_cmfb_top_0.dynamic_pcell_5_0.F_DRN 51.7595f
C175 m3_0_19899# slot5_wrapper_0.ibias1 0.15943f
C176 a_58930_33717# a_58930_33631# 0.01257f
C177 ota_cmfb_top_0.ota_cmfb_core_push_pull_output_stage_1/dynamic_pcell_4_0.B_DRN ota_cmfb_top_0.dynamic_pcell_5_0.F_DRN 0.02913f
C178 ota_cmfb_top_0.ota_cmfb_core_push_pull_output_stage_0/dynamic_pcell_4_0.DRN_NET_CD ota_cmfb_top_0.ota_cmfb_core_push_pull_output_stage_0/dynamic_pcell_4_0.SRC_NET_IJ_GATE_DI 6.10437f
C179 ota_cmfb_top_0.ota_cmfb_core_push_pull_output_stage_1/dynamic_pcell_4_0.DRN_NET_J_GATE_EJ ota_cmfb_top_0.dynamic_pcell_5_0.G_DRN 1.35323f
C180 a_51933_33717# a_51933_33917# 0.01257f
C181 ota_cmfb_top_0.dynamic_pcell_5_0.DRN_NET_BD ota_cmfb_top_0.dynamic_pcell_5_0.G_DRN 0.82835f
C182 a_51188_27218# a_50924_27132# 0.01257f
C183 ota_cmfb_top_0.ota_cmfb_core_push_pull_output_stage_0/dynamic_pcell_4_0.DRN_NET_HI ota_cmfb_top_0.ota_cmfb_core_push_pull_output_stage_0/dynamic_pcell_4_0.B_DRN 0.03502f
C184 s5_an[0] analog_bus0 0.21521f
C185 s5_an[2] ota_cmfb_top_0.ota_cmfb_core_push_pull_output_stage_1/dynamic_pcell_4_0.SRC_NET_IJ_GATE_DI 0.14627f
C186 ota_cmfb_top_0.dynamic_pcell_5_0.SRC_NET_AB ota_cmfb_top_0.dynamic_pcell_5_0.DRN_NET_IK_GATE_IJ 0.59718f
C187 a_52197_34240# a_51933_34240# 0.02325f
C188 analog_bus0 ota_cmfb_top_0.dynamic_pcell_5_0.SRC_NET_KL 1.69102f
C189 slot5_wrapper_0.dig_in[17] slot5_wrapper_0.dig_in[16] 0.23029f
C190 vdd_1v2 ota_cmfb_top_0.dynamic_pcell_5_0.G_DRN 51.7985f
C191 ota_cmfb_top_0.ota_cmfb_core_push_pull_output_stage_1/dynamic_pcell_4_0.B_DRN ota_cmfb_top_0.dynamic_pcell_5_0.G_DRN 5.94931f
C192 ota_cmfb_top_0.EN_INV_1/sg13cmos5l_inv_4_0.Y enable 0.38798f
C193 ota_cmfb_top_0.dynamic_pcell_5_0.L_GATE analog_bus0 0.17143f
C194 s5_an[2] a_58930_33631# 0.14737f
C195 ota_cmfb_top_0.dynamic_pcell_5_0.H_DRN analog_bus0 0.11409f
C196 ota_cmfb_top_0.ota_cmfb_core_push_pull_output_stage_0/dynamic_pcell_4_0.SRC_NET_QP_GATE_KLQ ota_cmfb_top_0.ota_cmfb_core_push_pull_output_stage_0/dynamic_pcell_4_0.SRC_NET_IJ_GATE_DI 0.02434f
C197 ota_cmfb_top_0.ota_cmfb_core_push_pull_output_stage_1/dynamic_pcell_4_0.DRN_NET_CD ota_cmfb_top_0.ota_cmfb_core_push_pull_output_stage_1/dynamic_pcell_4_0.DRN_NET_J_GATE_EJ 0.07255f
C198 ota_cmfb_top_0.ota_cmfb_core_push_pull_output_stage_1/dynamic_pcell_4_0.DRN_NET_CD ota_cmfb_top_0.dynamic_pcell_5_0.DRN_NET_BD 0.02878f
C199 slot5_wrapper_0.dig_out[5] slot5_wrapper_0.dig_out[4] 0.23029f
C200 ota_cmfb_top_0.ota_cmfb_core_push_pull_output_stage_0/dynamic_pcell_4_0.DRN_NET_OP_GATE_MP ota_cmfb_top_0.ota_cmfb_core_push_pull_output_stage_0/dynamic_pcell_4_0.B_DRN 3.54939f
C201 a_49604_27418# a_49604_27693# 0.0607f
C202 ota_cmfb_top_0.ota_cmfb_core_push_pull_output_stage_1/dynamic_pcell_4_0.DRN_NET_J_GATE_EJ s5_an[1] 0.08296f
C203 ota_cmfb_top_0.dynamic_pcell_5_0.DRN_NET_BD s5_an[1] 0.171f
C204 ota_cmfb_top_0.ota_cmfb_core_push_pull_output_stage_1/dynamic_pcell_4_0.DRN_NET_HI ota_cmfb_top_0.ota_cmfb_core_push_pull_output_stage_1/dynamic_pcell_4_0.SRC_NET_IJ_GATE_DI 3.70827f
C205 a_51933_34240# a_51669_34240# 0.02325f
C206 ota_cmfb_top_0.ota_cmfb_core_push_pull_output_stage_1/dynamic_pcell_4_0.DRN_NET_MENX ota_cmfb_top_0.dynamic_pcell_5_0.F_DRN 0.03936f
C207 ota_cmfb_top_0.dynamic_pcell_5_0.DRN_NET_JL ota_cmfb_top_0.EN_INV_0/sg13cmos5l_inv_4_0.Y 0.0296f
C208 vdd_1v2 ota_cmfb_top_0.ota_cmfb_core_push_pull_output_stage_1/dynamic_pcell_4_0.DRN_NET_CD 5.40593f
C209 ota_cmfb_top_0.ota_cmfb_core_push_pull_output_stage_1/dynamic_pcell_4_0.DRN_NET_CD ota_cmfb_top_0.ota_cmfb_core_push_pull_output_stage_1/dynamic_pcell_4_0.B_DRN 0.03703f
C210 m3_0_21663# slot5_wrapper_0.analog_bus2 0.15943f
C211 w_59515_33612# s5_an[2] 0.7703f
C212 slot5_wrapper_0.dig_out[9] slot5_wrapper_0.dig_out[8] 0.23029f
C213 slot5_wrapper_0.reset enable 0.22207f
C214 vdd_1v2 s5_an[1] 10.017f
C215 ota_cmfb_top_0.ota_cmfb_core_push_pull_output_stage_1/dynamic_pcell_4_0.B_DRN s5_an[1] 0.15492f
C216 ota_cmfb_top_0.ota_cmfb_core_push_pull_output_stage_0/dynamic_pcell_4_0.DRN_NET_J_GATE_EJ ota_cmfb_top_0.ota_cmfb_core_push_pull_output_stage_0/dynamic_pcell_4_0.B_DRN 1.48907f
C217 vdd_1v2 w_52782_33612# 2.28151f
C218 a_49604_27418# a_49076_27418# 0.01672f
C219 ota_cmfb_top_0.ota_cmfb_core_push_pull_output_stage_1/dynamic_pcell_4_0.DRN_NET_MENX ota_cmfb_top_0.dynamic_pcell_5_0.G_DRN 0.13609f
C220 vdd_1v2 ota_cmfb_top_0.EN_INV_1/sg13cmos5l_inv_4_0.Y 0.45533f
C221 analog_bus1 ota_cmfb_top_0.dynamic_pcell_5_0.DRN_NET_JL 0.08085f
C222 ota_cmfb_top_0.dynamic_pcell_5_0.DRN_NET_JL ota_cmfb_top_0.dynamic_pcell_5_0.DRN_NET_CA 1.56281f
C223 w_59515_33612# a_59194_34240# 0.02344f
C224 slot5_wrapper_0.dig_out[11] slot5_wrapper_0.dig_in[0] 0.05407f
C225 a_49868_27218# a_50132_27218# 0.02325f
C226 ota_cmfb_top_0.dynamic_pcell_5_0.L_GATE a_48812_27979# 0.01114f
C227 a_58666_34154# a_58666_33917# 0.07379f
C228 a_49340_27132# a_49868_27132# 0.01672f
C229 s5_an[1] a_52197_34240# 0.01822f
C230 ota_cmfb_top_0.dynamic_pcell_5_0.DRN_NET_BD enable 3.02675f
C231 ota_cmfb_top_0.ota_cmfb_core_push_pull_output_stage_0/dynamic_pcell_4_0.DRN_NET_MENX ota_cmfb_top_0.ota_cmfb_core_push_pull_output_stage_0/dynamic_pcell_4_0.DRN_NET_CD 0.04216f
C232 ota_cmfb_top_0.ota_cmfb_core_push_pull_output_stage_0/dynamic_pcell_4_0.DRN_NET_HI ota_cmfb_top_0.ota_cmfb_core_push_pull_output_stage_0/dynamic_pcell_4_0.DRN_NET_J_GATE_EJ 2.936f
C233 ota_cmfb_top_0.ota_cmfb_core_push_pull_output_stage_0/dynamic_pcell_4_0.SRC_NET_ML ota_cmfb_top_0.ota_cmfb_core_push_pull_output_stage_0/dynamic_pcell_4_0.SRC_NET_QP_GATE_KLQ 1.78674f
C234 s5_an[1] a_52197_33631# 0.14737f
C235 ota_cmfb_top_0.ota_cmfb_core_push_pull_output_stage_1/dynamic_pcell_4_0.DRN_NET_CD ota_cmfb_top_0.ota_cmfb_core_push_pull_output_stage_1/dynamic_pcell_4_0.DRN_NET_MENX 0.04205f
C236 a_51933_33917# a_51933_34154# 0.07379f
C237 vdd_1v2 enable 5.75864f
C238 slot5_wrapper_0.dig_in[23] slot5_wrapper_0.reset 0.23029f
C239 w_52782_33612# a_52197_33631# 0.01194f
C240 a_49868_27979# a_50132_27779# 0.01257f
C241 a_51933_33717# a_51669_33717# 0.02325f
C242 s5_an[1] ota_cmfb_top_0.ota_cmfb_core_push_pull_output_stage_1/dynamic_pcell_4_0.DRN_NET_MENX 0.25297f
C243 slot5_wrapper_0.vbias m3_0_18723# 0.15943f
C244 ota_cmfb_top_0.ota_cmfb_core_push_pull_output_stage_1/dynamic_pcell_4_0.DRN_NET_J_GATE_EJ ota_cmfb_top_0.dynamic_pcell_5_0.DRN_NET_BD 0.33729f
C245 ota_cmfb_top_0.dynamic_pcell_5_0.SRC_NET_AB analog_bus0 2.35414f
C246 ota_cmfb_top_0.ota_cmfb_core_push_pull_output_stage_0/dynamic_pcell_4_0.DRN_NET_OP_GATE_MP ota_cmfb_top_0.ota_cmfb_core_push_pull_output_stage_0/dynamic_pcell_4_0.DRN_NET_J_GATE_EJ 0.30098f
C247 ota_cmfb_top_0.ota_cmfb_core_push_pull_output_stage_0/dynamic_pcell_4_0.SRC_NET_QP_GATE_KLQ ota_cmfb_top_0.ota_cmfb_core_push_pull_output_stage_0/dynamic_pcell_4_0.DRN_NET_MENX 0.50655f
C248 a_50396_27132# a_50924_27132# 0.01672f
C249 vdd_1v2 a_51188_27779# 0.01125f
C250 a_52461_34240# a_52197_34440# 0.01257f
C251 s5_an[0] ota_cmfb_top_0.dynamic_pcell_5_0.DRN_NET_JL 0.04861f
C252 ota_cmfb_top_0.ota_cmfb_core_push_pull_output_stage_1/dynamic_pcell_4_0.DRN_NET_J_GATE_EJ ota_cmfb_top_0.ota_cmfb_core_push_pull_output_stage_1/dynamic_pcell_4_0.B_DRN 1.48218f
C253 vdd_1v2 ota_cmfb_top_0.ota_cmfb_core_push_pull_output_stage_1/dynamic_pcell_4_0.DRN_NET_J_GATE_EJ 14.6277f
C254 vdd_1v2 ota_cmfb_top_0.dynamic_pcell_5_0.DRN_NET_BD 12.4341f
C255 ota_cmfb_top_0.dynamic_pcell_5_0.DRN_NET_BD ota_cmfb_top_0.ota_cmfb_core_push_pull_output_stage_1/dynamic_pcell_4_0.B_DRN 0.02593f
C256 ota_cmfb_top_0.dynamic_pcell_5_0.DRN_NET_CA ota_cmfb_top_0.dynamic_pcell_5_0.F_DRN 2.64062f
C257 a_49076_27779# a_49340_27779# 0.02325f
C258 ota_cmfb_top_0.dynamic_pcell_5_0.DRN_NET_JL ota_cmfb_top_0.dynamic_pcell_5_0.SRC_NET_KL 1.66968f
C259 a_58930_33631# a_59194_33717# 0.01257f
C260 a_50924_27218# a_50660_27218# 0.02325f
C261 slot5_wrapper_0.dig_in[3] slot5_wrapper_0.dig_in[4] 0.23029f
C262 s5_an[2] ota_cmfb_top_0.ota_cmfb_core_push_pull_output_stage_0/dynamic_pcell_4_0.B_DRN 0.10479f
C263 vdd_1v2 ota_cmfb_top_0.ota_cmfb_core_push_pull_output_stage_1/dynamic_pcell_4_0.B_DRN 6.42284f
C264 ota_cmfb_top_0.dynamic_pcell_5_0.L_GATE ota_cmfb_top_0.dynamic_pcell_5_0.DRN_NET_JL 5.58516f
C265 ota_cmfb_top_0.dynamic_pcell_5_0.H_DRN ota_cmfb_top_0.dynamic_pcell_5_0.DRN_NET_JL 0.37101f
C266 a_50924_27979# a_50924_27779# 0.01257f
C267 ota_cmfb_top_0.ota_cmfb_core_push_pull_output_stage_0/dynamic_pcell_4_0.DRN_NET_CD ota_cmfb_top_0.dynamic_pcell_5_0.F_DRN 3.46067f
C268 a_58666_34154# a_58930_34240# 0.01257f
C269 w_59515_33612# a_59194_33717# 0.01719f
C270 ota_cmfb_top_0.dynamic_pcell_5_0.DRN_NET_CA ota_cmfb_top_0.dynamic_pcell_5_0.G_DRN 12.4965f
C271 ibias0 m3_0_19311# 0.15943f
C272 slot5_wrapper_0.dig_out[6] slot5_wrapper_0.dig_out[5] 0.23029f
C273 slot5_wrapper_0.dig_in[9] slot5_wrapper_0.dig_in[8] 0.23029f
C274 s5_an[2] a_58666_34154# 0.1112f
C275 vdd_1v2 a_58402_34440# 0.03055f
C276 slot5_wrapper_0.dig_in[18] slot5_wrapper_0.dig_in[17] 0.23029f
C277 a_58666_34240# a_58402_34440# 0.01257f
C278 ota_cmfb_top_0.ota_cmfb_core_push_pull_output_stage_1/dynamic_pcell_4_0.SRC_NET_QP_GATE_KLQ ota_cmfb_top_0.dynamic_pcell_5_0.F_DRN 0.19113f
C279 a_49604_27418# a_49604_27218# 0.01257f
C280 a_50396_27779# a_50132_27779# 0.02325f
C281 slot5_wrapper_0.vss_3v3 slot5_wrapper_0.vdd_3v3 0.01435f
C282 ota_cmfb_top_0.ota_cmfb_core_push_pull_output_stage_1/dynamic_pcell_4_0.DRN_NET_J_GATE_EJ ota_cmfb_top_0.ota_cmfb_core_push_pull_output_stage_1/dynamic_pcell_4_0.DRN_NET_MENX 7.45951f
C283 ota_cmfb_top_0.ota_cmfb_core_push_pull_output_stage_1/dynamic_pcell_4_0.SRC_NET_ML ota_cmfb_top_0.dynamic_pcell_5_0.F_DRN 0.60054f
C284 ota_cmfb_top_0.dynamic_pcell_5_0.DRN_NET_BD ota_cmfb_top_0.ota_cmfb_core_push_pull_output_stage_1/dynamic_pcell_4_0.DRN_NET_MENX 0.05014f
C285 vdd_1v2 a_52197_33631# 0.03244f
C286 analog_bus0 m3_0_22251# 0.15943f
C287 s5_an[0] ota_cmfb_top_0.dynamic_pcell_5_0.F_DRN 0.03255f
C288 ota_cmfb_top_0.ota_cmfb_core_push_pull_output_stage_1/dynamic_pcell_4_0.DRN_NET_CD ota_cmfb_top_0.dynamic_pcell_5_0.DRN_NET_CA 4.90958f
C289 ota_cmfb_top_0.ota_cmfb_core_push_pull_output_stage_0/dynamic_pcell_4_0.SRC_NET_QP_GATE_KLQ ota_cmfb_top_0.dynamic_pcell_5_0.F_DRN 0.20917f
C290 a_52461_33717# a_52197_33717# 0.02325f
C291 a_50924_27979# s5_an[2] 0.01389f
C292 a_58930_33717# a_58666_33917# 0.01257f
C293 a_48812_27132# a_49076_27218# 0.01257f
C294 a_50660_27693# a_50660_27779# 0.01257f
C295 s5_an[1] a_51933_33717# 0.01404f
C296 vdd_1v2 ota_cmfb_top_0.ota_cmfb_core_push_pull_output_stage_1/dynamic_pcell_4_0.DRN_NET_MENX 3.22677f
C297 ota_cmfb_top_0.ota_cmfb_core_push_pull_output_stage_1/dynamic_pcell_4_0.B_DRN ota_cmfb_top_0.ota_cmfb_core_push_pull_output_stage_1/dynamic_pcell_4_0.DRN_NET_MENX 0.78705f
C298 s5_an[2] ota_cmfb_top_0.ota_cmfb_core_push_pull_output_stage_0/dynamic_pcell_4_0.DRN_NET_OP_GATE_MP 0.46756f
C299 s5_an[1] ota_cmfb_top_0.dynamic_pcell_5_0.DRN_NET_CA 0.69582f
C300 ota_cmfb_top_0.ota_cmfb_core_push_pull_output_stage_1/dynamic_pcell_4_0.SRC_NET_QP_GATE_KLQ ota_cmfb_top_0.dynamic_pcell_5_0.G_DRN 0.02764f
C301 vdd_1v2 a_51669_34240# 0.01418f
C302 slot5_wrapper_0.dig_in[21] slot5_wrapper_0.dig_in[20] 0.23029f
C303 a_50924_27979# a_50396_27979# 0.01672f
C304 ota_cmfb_top_0.ota_cmfb_core_push_pull_output_stage_0/dynamic_pcell_4_0.SRC_NET_IJ_GATE_DI ota_cmfb_top_0.ota_cmfb_core_push_pull_output_stage_0/dynamic_pcell_4_0.B_DRN 1.72011f
C305 ota_cmfb_top_0.dynamic_pcell_5_0.H_DRN ota_cmfb_top_0.dynamic_pcell_5_0.F_DRN 0.88459f
C306 w_52782_33612# ota_cmfb_top_0.dynamic_pcell_5_0.DRN_NET_CA 9.5166f
C307 a_51669_33631# a_51669_33717# 0.01257f
C308 vdd_1v2 a_58402_33631# 0.05193f
C309 ota_cmfb_top_0.EN_INV_0/sg13cmos5l_inv_4_0.Y enable 0.40609f
C310 a_50396_27218# a_50660_27218# 0.02325f
C311 a_51933_34240# a_51933_34154# 0.01257f
C312 s5_an[1] ota_cmfb_top_0.ota_cmfb_core_push_pull_output_stage_0/dynamic_pcell_4_0.DRN_NET_CD 0.01712f
C313 s5_an[2] ota_cmfb_top_0.ota_cmfb_core_push_pull_output_stage_0/dynamic_pcell_4_0.DRN_NET_J_GATE_EJ 0.02831f
C314 s5_an[2] a_58666_33917# 0.129f
C315 ota_cmfb_top_0.ota_cmfb_core_push_pull_output_stage_0/dynamic_pcell_4_0.DRN_NET_HI ota_cmfb_top_0.ota_cmfb_core_push_pull_output_stage_0/dynamic_pcell_4_0.SRC_NET_IJ_GATE_DI 3.72801f
C316 a_50396_27218# a_50132_27418# 0.01257f
C317 a_49604_27693# a_49868_27779# 0.01257f
C318 ota_cmfb_top_0.dynamic_pcell_5_0.H_DRN ota_cmfb_top_0.dynamic_pcell_5_0.G_DRN 0.10057f
C319 slot5_wrapper_0.dig_out[9] slot5_wrapper_0.dig_out[10] 0.23029f
C320 ota_cmfb_top_0.dynamic_pcell_5_0.SRC_NET_AB ota_cmfb_top_0.dynamic_pcell_5_0.DRN_NET_JL 3.03473f
C321 s5_an[1] ota_cmfb_top_0.ota_cmfb_core_push_pull_output_stage_1/dynamic_pcell_4_0.SRC_NET_QP_GATE_KLQ 0.03639f
C322 analog_bus1 enable 0.40791f
C323 ota_cmfb_top_0.dynamic_pcell_5_0.DRN_NET_CA enable 0.01702f
C324 slot5_wrapper_0.dig_in[23] slot5_wrapper_0.dig_in[22] 0.23029f
C325 s5_an[1] ota_cmfb_top_0.ota_cmfb_core_push_pull_output_stage_1/dynamic_pcell_4_0.SRC_NET_ML 0.07626f
C326 ibias0 ota_cmfb_top_0.dynamic_pcell_5_0.DRN_NET_IK_GATE_IJ 4.87541f
C327 a_50396_27979# a_49868_27979# 0.01672f
C328 a_58402_33717# a_58402_33631# 0.01257f
C329 vdd_1v2 a_58402_33917# 0.02884f
C330 a_49340_27218# a_49076_27218# 0.02325f
C331 vdd_1v2 ota_cmfb_top_0.EN_INV_0/sg13cmos5l_inv_4_0.Y 0.4623f
C332 ota_cmfb_top_0.dynamic_pcell_5_0.G_DRN ota_cmfb_top_0.ota_cmfb_core_push_pull_output_stage_1/dynamic_pcell_4_0.SRC_NET_IJ_GATE_DI 2.26021f
C333 ota_cmfb_top_0.ota_cmfb_core_push_pull_output_stage_0/dynamic_pcell_4_0.SRC_NET_ML ota_cmfb_top_0.ota_cmfb_core_push_pull_output_stage_0/dynamic_pcell_4_0.B_DRN 0.42237f
C334 analog_bus1 ota_cmfb_top_0.dynamic_pcell_5_0.DRN_NET_BD 8.88286f
C335 ota_cmfb_top_0.ota_cmfb_core_push_pull_output_stage_1/dynamic_pcell_4_0.DRN_NET_J_GATE_EJ ota_cmfb_top_0.dynamic_pcell_5_0.DRN_NET_CA 0.67943f
C336 ota_cmfb_top_0.dynamic_pcell_5_0.H_DRN s5_an[1] 0.011f
C337 a_52197_34440# a_51669_34440# 0.01672f
C338 ota_cmfb_top_0.dynamic_pcell_5_0.DRN_NET_BD ota_cmfb_top_0.dynamic_pcell_5_0.DRN_NET_CA 5.97276f
C339 a_58930_33717# s5_an[2] 0.01822f
C340 m3_0_21075# slot5_wrapper_0.analog_bus2 0.15943f
C341 ota_cmfb_top_0.dynamic_pcell_5_0.L_GATE ota_cmfb_top_0.EN_INV_1/sg13cmos5l_inv_4_0.Y 0.14674f
C342 vdd_1v2 analog_bus1 18.3522f
C343 ota_cmfb_top_0.ota_cmfb_core_push_pull_output_stage_1/dynamic_pcell_4_0.DRN_NET_CD ota_cmfb_top_0.ota_cmfb_core_push_pull_output_stage_1/dynamic_pcell_4_0.SRC_NET_IJ_GATE_DI 6.08314f
C344 vdd_1v2 ota_cmfb_top_0.dynamic_pcell_5_0.DRN_NET_CA 11.1172f
C345 ota_cmfb_top_0.ota_cmfb_core_push_pull_output_stage_0/dynamic_pcell_4_0.DRN_NET_J_GATE_EJ ota_cmfb_top_0.ota_cmfb_core_push_pull_output_stage_0/dynamic_pcell_4_0.SRC_NET_IJ_GATE_DI 5.83794f
C346 ota_cmfb_top_0.ota_cmfb_core_push_pull_output_stage_1/dynamic_pcell_4_0.B_DRN ota_cmfb_top_0.dynamic_pcell_5_0.DRN_NET_CA 2.63306f
C347 analog_bus0 ota_cmfb_top_0.dynamic_pcell_5_0.DRN_NET_IK_GATE_IJ 0.06849f
C348 s5_an[1] a_51933_34154# 0.1128f
C349 a_58402_33717# a_58402_33917# 0.01242f
C350 ota_cmfb_top_0.ota_cmfb_core_push_pull_output_stage_0/dynamic_pcell_4_0.DRN_NET_MENX ota_cmfb_top_0.ota_cmfb_core_push_pull_output_stage_0/dynamic_pcell_4_0.B_DRN 0.78705f
C351 s5_an[0] enable 0.94653f
C352 ota_cmfb_top_0.dynamic_pcell_5_0.DRN_NET_BD ota_cmfb_top_0.ota_cmfb_core_push_pull_output_stage_0/dynamic_pcell_4_0.DRN_NET_CD 4.72903f
C353 s5_an[1] ota_cmfb_top_0.ota_cmfb_core_push_pull_output_stage_1/dynamic_pcell_4_0.SRC_NET_IJ_GATE_DI 0.24349f
C354 s5_an[1] a_51669_33631# 0.04349f
C355 w_52782_33612# a_51933_34154# 0.01701f
C356 s5_an[2] a_58930_34240# 0.01822f
C357 a_50132_27693# a_50132_27418# 0.0607f
C358 a_58666_33717# a_58402_33717# 0.02325f
C359 a_58402_34440# a_58930_34440# 0.01672f
C360 ota_cmfb_top_0.ota_cmfb_core_push_pull_output_stage_1/dynamic_pcell_4_0.DRN_NET_J_GATE_EJ ota_cmfb_top_0.ota_cmfb_core_push_pull_output_stage_1/dynamic_pcell_4_0.SRC_NET_QP_GATE_KLQ 6.34946f
C361 vdd_1v2 ota_cmfb_top_0.ota_cmfb_core_push_pull_output_stage_0/dynamic_pcell_4_0.DRN_NET_CD 5.38769f
C362 ota_cmfb_top_0.dynamic_pcell_5_0.L_GATE enable 0.11635f
C363 a_51933_33917# a_51669_33917# 0.01702f
C364 ota_cmfb_top_0.dynamic_pcell_5_0.H_DRN enable 0.03252f
C365 ota_cmfb_top_0.ota_cmfb_core_push_pull_output_stage_0/dynamic_pcell_4_0.DRN_NET_HI ota_cmfb_top_0.ota_cmfb_core_push_pull_output_stage_0/dynamic_pcell_4_0.DRN_NET_MENX 0.09346f
C366 ota_cmfb_top_0.ota_cmfb_core_push_pull_output_stage_1/dynamic_pcell_4_0.DRN_NET_J_GATE_EJ ota_cmfb_top_0.ota_cmfb_core_push_pull_output_stage_1/dynamic_pcell_4_0.SRC_NET_ML 0.07184f
C367 a_49340_27979# a_49604_27779# 0.01257f
C368 ota_cmfb_top_0.ota_cmfb_core_push_pull_output_stage_0/dynamic_pcell_4_0.SRC_NET_ML ota_cmfb_top_0.ota_cmfb_core_push_pull_output_stage_0/dynamic_pcell_4_0.DRN_NET_OP_GATE_MP 2.78684f
C369 a_58666_33717# a_58402_33631# 0.01257f
C370 slot5_wrapper_0.dig_out[3] slot5_wrapper_0.dig_out[4] 0.23029f
C371 a_50396_27979# a_50396_27779# 0.01257f
C372 ota_cmfb_top_0.dynamic_pcell_5_0.DRN_NET_BD s5_an[0] 0.03837f
C373 ota_cmfb_top_0.dynamic_pcell_5_0.DRN_NET_BD ota_cmfb_top_0.ota_cmfb_core_push_pull_output_stage_0/dynamic_pcell_4_0.SRC_NET_QP_GATE_KLQ 0.04935f
C374 vdd_1v2 ota_cmfb_top_0.ota_cmfb_core_push_pull_output_stage_1/dynamic_pcell_4_0.SRC_NET_QP_GATE_KLQ 0.04027f
C375 a_59194_34240# a_58930_34240# 0.02325f
C376 ota_cmfb_top_0.ota_cmfb_core_push_pull_output_stage_1/dynamic_pcell_4_0.B_DRN ota_cmfb_top_0.ota_cmfb_core_push_pull_output_stage_1/dynamic_pcell_4_0.SRC_NET_QP_GATE_KLQ 0.76289f
C377 slot5_wrapper_0.dig_out[7] slot5_wrapper_0.dig_out[8] 0.23029f
C378 s5_an[2] a_59194_34240# 0.01599f
C379 ota_cmfb_top_0.dynamic_pcell_5_0.DRN_NET_BD ota_cmfb_top_0.dynamic_pcell_5_0.SRC_NET_KL 0.03997f
C380 ota_cmfb_top_0.ota_cmfb_core_push_pull_output_stage_1/dynamic_pcell_4_0.B_DRN ota_cmfb_top_0.ota_cmfb_core_push_pull_output_stage_1/dynamic_pcell_4_0.SRC_NET_ML 0.42237f
C381 a_50660_27693# a_50132_27693# 0.01672f
C382 ota_cmfb_top_0.ota_cmfb_core_push_pull_output_stage_1/dynamic_pcell_4_0.DRN_NET_MENX ota_cmfb_top_0.dynamic_pcell_5_0.DRN_NET_CA 4.81779f
C383 slot5_wrapper_0.dig_in[7] slot5_wrapper_0.dig_in[6] 0.23029f
C384 slot5_wrapper_0.clk m3_0_18723# 0.01706f
C385 vdd_1v2 s5_an[0] 2.93423f
C386 s5_an[2] ota_cmfb_top_0.ota_cmfb_core_push_pull_output_stage_1/dynamic_pcell_4_0.DRN_NET_HI 0.01984f
C387 vdd_1v2 ota_cmfb_top_0.ota_cmfb_core_push_pull_output_stage_0/dynamic_pcell_4_0.SRC_NET_QP_GATE_KLQ 0.04022f
C388 a_48812_27779# a_48812_27979# 0.01257f
C389 ota_cmfb_top_0.dynamic_pcell_5_0.DRN_NET_BD ota_cmfb_top_0.dynamic_pcell_5_0.L_GATE 0.09133f
C390 ota_cmfb_top_0.dynamic_pcell_5_0.DRN_NET_BD ota_cmfb_top_0.dynamic_pcell_5_0.H_DRN 2.74139f
C391 ota_cmfb_top_0.ota_cmfb_core_push_pull_output_stage_0/dynamic_pcell_4_0.DRN_NET_OP_GATE_MP ota_cmfb_top_0.ota_cmfb_core_push_pull_output_stage_0/dynamic_pcell_4_0.DRN_NET_MENX 5.62824f
C392 ota_cmfb_top_0.ota_cmfb_core_push_pull_output_stage_0/dynamic_pcell_4_0.SRC_NET_ML ota_cmfb_top_0.ota_cmfb_core_push_pull_output_stage_0/dynamic_pcell_4_0.DRN_NET_J_GATE_EJ 0.07184f
C393 vdd_1v2 ota_cmfb_top_0.dynamic_pcell_5_0.SRC_NET_KL 6.57908f
C394 slot5_wrapper_0.dig_in[8] slot5_wrapper_0.dig_in[7] 0.23029f
C395 a_49340_27132# a_49604_27218# 0.01257f
C396 slot5_wrapper_0.dig_in[15] slot5_wrapper_0.dig_in[16] 0.23029f
C397 vdd_1v2 ota_cmfb_top_0.dynamic_pcell_5_0.L_GATE 4.40184f
C398 vdd_1v2 ota_cmfb_top_0.dynamic_pcell_5_0.H_DRN 31.5953f
C399 a_49340_27979# a_49868_27979# 0.01672f
C400 ota_cmfb_top_0.ota_cmfb_core_push_pull_output_stage_0/dynamic_pcell_4_0.B_DRN ota_cmfb_top_0.dynamic_pcell_5_0.F_DRN 6.08486f
C401 ota_cmfb_top_0.ota_cmfb_core_push_pull_output_stage_1/dynamic_pcell_4_0.DRN_NET_J_GATE_EJ ota_cmfb_top_0.ota_cmfb_core_push_pull_output_stage_1/dynamic_pcell_4_0.SRC_NET_IJ_GATE_DI 5.83093f
C402 ota_cmfb_top_0.dynamic_pcell_5_0.DRN_NET_BD ota_cmfb_top_0.ota_cmfb_core_push_pull_output_stage_1/dynamic_pcell_4_0.SRC_NET_IJ_GATE_DI 0.53521f
C403 s5_an[2] ota_cmfb_top_0.ota_cmfb_core_push_pull_output_stage_0/dynamic_pcell_4_0.SRC_NET_IJ_GATE_DI 0.18208f
C404 ota_cmfb_top_0.ota_cmfb_core_push_pull_output_stage_0/dynamic_pcell_4_0.DRN_NET_MENX ota_cmfb_top_0.ota_cmfb_core_push_pull_output_stage_0/dynamic_pcell_4_0.DRN_NET_J_GATE_EJ 7.51402f
C405 ota_cmfb_top_0.ota_cmfb_core_push_pull_output_stage_1/dynamic_pcell_4_0.DRN_NET_MENX ota_cmfb_top_0.ota_cmfb_core_push_pull_output_stage_1/dynamic_pcell_4_0.SRC_NET_QP_GATE_KLQ 0.50655f
C406 a_49076_27779# a_49076_27693# 0.01257f
C407 slot5_wrapper_0.dig_out[2] slot5_wrapper_0.dig_out[1] 0.23029f
C408 a_50132_27693# a_49604_27693# 0.01672f
C409 ota_cmfb_top_0.ota_cmfb_core_push_pull_output_stage_1/dynamic_pcell_4_0.DRN_NET_MENX ota_cmfb_top_0.ota_cmfb_core_push_pull_output_stage_1/dynamic_pcell_4_0.SRC_NET_ML 2.93711f
C410 ota_cmfb_top_0.ota_cmfb_core_push_pull_output_stage_1/dynamic_pcell_4_0.B_DRN ota_cmfb_top_0.ota_cmfb_core_push_pull_output_stage_1/dynamic_pcell_4_0.SRC_NET_IJ_GATE_DI 1.71592f
C411 vdd_1v2 ota_cmfb_top_0.ota_cmfb_core_push_pull_output_stage_1/dynamic_pcell_4_0.SRC_NET_IJ_GATE_DI 17.5356f
C412 a_58930_33717# a_59194_33717# 0.02325f
C413 vdd_1v2 a_51669_33631# 0.05819f
C414 ota_cmfb_top_0.ota_cmfb_core_push_pull_output_stage_0/dynamic_pcell_4_0.DRN_NET_HI ota_cmfb_top_0.dynamic_pcell_5_0.F_DRN 4.57567f
C415 ota_cmfb_top_0.dynamic_pcell_5_0.DRN_NET_CA a_58402_33917# 0.01179f
C416 a_52197_33717# a_51933_33917# 0.01257f
C417 slot5_wrapper_0.dig_out[7] slot5_wrapper_0.dig_out[6] 0.23029f
C418 s5_an[1] a_52461_34240# 0.01599f
C419 vdd_1v2 a_58930_33631# 0.03236f
C420 a_52197_34240# a_51933_34154# 0.01257f
C421 slot5_wrapper_0.dig_in[2] slot5_wrapper_0.dig_in[1] 0.23029f
C422 ota_cmfb_top_0.ota_cmfb_core_push_pull_output_stage_1/dynamic_pcell_4_0.DRN_NET_OP_GATE_MP ota_cmfb_top_0.dynamic_pcell_5_0.F_DRN 0.10016f
C423 slot5_wrapper_0.vss_3v3 analog_bus0 0.06022f
C424 ota_cmfb_top_0.dynamic_pcell_5_0.DRN_NET_BD w_59515_33612# 9.5159f
C425 w_52782_33612# a_52461_34240# 0.02344f
C426 ota_cmfb_top_0.dynamic_pcell_5_0.DRN_NET_JL ota_cmfb_top_0.dynamic_pcell_5_0.DRN_NET_IK_GATE_IJ 5.76497f
C427 slot5_wrapper_0.dig_in[19] slot5_wrapper_0.dig_in[20] 0.23029f
C428 a_51669_33717# a_51669_33917# 0.01242f
C429 s5_an[2] a_59194_33717# 0.02891f
C430 slot5_wrapper_0.dig_in[19] slot5_wrapper_0.dig_in[18] 0.23029f
C431 a_49604_27418# a_49868_27218# 0.01257f
C432 ota_cmfb_top_0.ota_cmfb_core_push_pull_output_stage_0/dynamic_pcell_4_0.DRN_NET_OP_GATE_MP ota_cmfb_top_0.dynamic_pcell_5_0.F_DRN 0.12064f
C433 a_52197_33631# a_51669_33631# 0.01672f
C434 vdd_1v2 w_59515_33612# 2.06977f
C435 s5_an[1] a_51188_27218# 0.02144f
C436 analog_bus1 ota_cmfb_top_0.dynamic_pcell_5_0.DRN_NET_CA 2.12718f
C437 slot5_wrapper_0.dig_in[5] slot5_wrapper_0.dig_in[4] 0.23029f
C438 s5_an[2] ota_cmfb_top_0.ota_cmfb_core_push_pull_output_stage_0/dynamic_pcell_4_0.SRC_NET_ML 0.0758f
C439 ota_cmfb_top_0.dynamic_pcell_5_0.L_GATE a_48812_27218# 0.01681f
C440 ota_cmfb_top_0.ota_cmfb_core_push_pull_output_stage_1/dynamic_pcell_4_0.DRN_NET_OP_GATE_MP ota_cmfb_top_0.dynamic_pcell_5_0.G_DRN 0.02905f
C441 s5_an[1] ota_cmfb_top_0.ota_cmfb_core_push_pull_output_stage_0/dynamic_pcell_4_0.B_DRN 0.0508f
C442 ota_cmfb_top_0.dynamic_pcell_5_0.DRN_NET_BD ota_cmfb_top_0.dynamic_pcell_5_0.SRC_NET_AB 2.50866f
C443 ota_cmfb_top_0.ota_cmfb_core_push_pull_output_stage_1/dynamic_pcell_4_0.DRN_NET_MENX ota_cmfb_top_0.ota_cmfb_core_push_pull_output_stage_1/dynamic_pcell_4_0.SRC_NET_IJ_GATE_DI 0.13705f
C444 ota_cmfb_top_0.ota_cmfb_core_push_pull_output_stage_0/dynamic_pcell_4_0.DRN_NET_J_GATE_EJ ota_cmfb_top_0.dynamic_pcell_5_0.F_DRN 1.60884f
C445 a_49076_27693# a_49340_27779# 0.01257f
C446 vdd_1v2 ota_cmfb_top_0.dynamic_pcell_5_0.SRC_NET_AB 5.96391f
C447 s5_an[2] ota_cmfb_top_0.ota_cmfb_core_push_pull_output_stage_0/dynamic_pcell_4_0.DRN_NET_MENX 0.19927f
C448 s5_an[1] a_50924_27132# 0.01503f
C449 a_58930_33631# a_58402_33631# 0.01672f
C450 ota_cmfb_top_0.dynamic_pcell_5_0.L_GATE a_49076_27418# 0.01688f
C451 ota_cmfb_top_0.dynamic_pcell_5_0.DRN_NET_IK_GATE_IJ ota_cmfb_top_0.dynamic_pcell_5_0.F_DRN 0.04168f
C452 ota_cmfb_top_0.dynamic_pcell_5_0.DRN_NET_CA ota_cmfb_top_0.ota_cmfb_core_push_pull_output_stage_1/dynamic_pcell_4_0.SRC_NET_QP_GATE_KLQ 0.04935f
C453 a_49868_27132# a_50132_27218# 0.01257f
C454 s5_an[1] ota_cmfb_top_0.ota_cmfb_core_push_pull_output_stage_1/dynamic_pcell_4_0.DRN_NET_OP_GATE_MP 0.47087f
C455 ota_cmfb_top_0.dynamic_pcell_5_0.L_GATE ota_cmfb_top_0.EN_INV_0/sg13cmos5l_inv_4_0.Y 0.14067f
C456 ota_cmfb_top_0.dynamic_pcell_5_0.DRN_NET_CA ota_cmfb_top_0.ota_cmfb_core_push_pull_output_stage_1/dynamic_pcell_4_0.SRC_NET_ML 0.02128f
C457 ibias0 ota_cmfb_top_0.dynamic_pcell_5_0.DRN_NET_JL 0.25247f
C458 a_51933_34240# a_51669_34440# 0.01257f
C459 analog_bus1 s5_an[0] 0.24007f
C460 s5_an[0] ota_cmfb_top_0.dynamic_pcell_5_0.DRN_NET_CA 0.03423f
C461 s5_an[1] a_52461_33717# 0.02891f
C462 analog_bus1 ota_cmfb_top_0.dynamic_pcell_5_0.SRC_NET_KL 1.55605f
C463 ota_cmfb_top_0.dynamic_pcell_5_0.DRN_NET_CA ota_cmfb_top_0.dynamic_pcell_5_0.SRC_NET_KL 0.05257f
C464 ota_cmfb_top_0.dynamic_pcell_5_0.DRN_NET_IK_GATE_IJ ota_cmfb_top_0.dynamic_pcell_5_0.G_DRN 0.05316f
C465 a_49076_27693# a_49604_27693# 0.01672f
C466 w_52782_33612# a_52461_33717# 0.01719f
C467 analog_bus1 m3_0_21663# 0.15943f
C468 analog_bus1 ota_cmfb_top_0.dynamic_pcell_5_0.L_GATE 0.1169f
C469 analog_bus1 ota_cmfb_top_0.dynamic_pcell_5_0.H_DRN 0.0303f
C470 ota_cmfb_top_0.dynamic_pcell_5_0.L_GATE ota_cmfb_top_0.dynamic_pcell_5_0.DRN_NET_CA 3.24676f
C471 ota_cmfb_top_0.dynamic_pcell_5_0.H_DRN ota_cmfb_top_0.dynamic_pcell_5_0.DRN_NET_CA 0.04573f
C472 ota_cmfb_top_0.dynamic_pcell_5_0.DRN_NET_BD ota_cmfb_top_0.ota_cmfb_core_push_pull_output_stage_0/dynamic_pcell_4_0.B_DRN 2.5878f
C473 s5_an[1] a_51669_33917# 0.01687f
C474 m3_0_21075# slot5_wrapper_0.analog_bus3 0.15943f
C475 analog_bus0 ota_cmfb_top_0.dynamic_pcell_5_0.DRN_NET_JL 0.09711f
C476 s5_an[1] ota_cmfb_top_0.ota_cmfb_core_push_pull_output_stage_0/dynamic_pcell_4_0.DRN_NET_J_GATE_EJ 0.05904f
C477 vdd_1v2 a_51188_27218# 0.01255f
C478 ota_cmfb_top_0.ota_cmfb_core_push_pull_output_stage_1/dynamic_pcell_4_0.SRC_NET_ML ota_cmfb_top_0.ota_cmfb_core_push_pull_output_stage_1/dynamic_pcell_4_0.SRC_NET_QP_GATE_KLQ 1.78674f
C479 a_52461_34240# a_52197_34240# 0.02325f
C480 ota_cmfb_top_0.ota_cmfb_core_push_pull_output_stage_0/dynamic_pcell_4_0.DRN_NET_MENX ota_cmfb_top_0.ota_cmfb_core_push_pull_output_stage_0/dynamic_pcell_4_0.SRC_NET_IJ_GATE_DI 0.13717f
C481 vdd_1v2 ota_cmfb_top_0.ota_cmfb_core_push_pull_output_stage_0/dynamic_pcell_4_0.B_DRN 6.41039f
C482 slot5_wrapper_0.dig_out[11] slot5_wrapper_0.dig_out[10] 0.23029f
C483 a_49076_27693# a_49076_27418# 0.0607f
C484 a_51933_33717# a_51669_33631# 0.01257f
C485 ota_cmfb_top_0.dynamic_pcell_5_0.DRN_NET_CA ota_cmfb_top_0.ota_cmfb_core_push_pull_output_stage_1/dynamic_pcell_4_0.SRC_NET_IJ_GATE_DI 4.88321f
C486 a_51188_27218# a_50924_27218# 0.02325f
C487 ota_cmfb_top_0.dynamic_pcell_5_0.DRN_NET_BD ota_cmfb_top_0.ota_cmfb_core_push_pull_output_stage_0/dynamic_pcell_4_0.DRN_NET_HI 0.27505f
C488 s5_an[2] ota_cmfb_top_0.dynamic_pcell_5_0.F_DRN 0.25538f
C489 a_48812_27979# a_49340_27979# 0.01672f
C490 a_50132_27418# a_50132_27218# 0.01257f
C491 ibias0 ota_cmfb_top_0.dynamic_pcell_5_0.F_DRN 2.58831f
C492 a_49868_27218# a_49868_27132# 0.01257f
C493 s5_an[0] ota_cmfb_top_0.dynamic_pcell_5_0.SRC_NET_KL 0.53308f
C494 ota_cmfb_top_0.ota_cmfb_core_push_pull_output_stage_1/dynamic_pcell_4_0.DRN_NET_J_GATE_EJ ota_cmfb_top_0.ota_cmfb_core_push_pull_output_stage_1/dynamic_pcell_4_0.DRN_NET_OP_GATE_MP 0.30098f
C495 a_58666_34240# a_58666_34154# 0.01257f
C496 a_50924_27979# a_51188_27779# 0.01257f
C497 vdd_1v2 ota_cmfb_top_0.ota_cmfb_core_push_pull_output_stage_0/dynamic_pcell_4_0.DRN_NET_HI 2.74927f
C498 s5_an[1] a_51669_34440# 0.04516f
C499 s5_an[0] ota_cmfb_top_0.dynamic_pcell_5_0.L_GATE 0.12532f
C500 s5_an[0] ota_cmfb_top_0.dynamic_pcell_5_0.H_DRN 0.35977f
C501 s5_an[2] ota_cmfb_top_0.dynamic_pcell_5_0.G_DRN 0.35275f
C502 s5_an[1] a_50660_27418# 0.02304f
C503 vdd_1v2 ota_cmfb_top_0.ota_cmfb_core_push_pull_output_stage_1/dynamic_pcell_4_0.DRN_NET_OP_GATE_MP 0.01971f
C504 ota_cmfb_top_0.dynamic_pcell_5_0.DRN_NET_BD ota_cmfb_top_0.ota_cmfb_core_push_pull_output_stage_0/dynamic_pcell_4_0.DRN_NET_OP_GATE_MP 0.04023f
C505 ota_cmfb_top_0.ota_cmfb_core_push_pull_output_stage_1/dynamic_pcell_4_0.B_DRN ota_cmfb_top_0.ota_cmfb_core_push_pull_output_stage_1/dynamic_pcell_4_0.DRN_NET_OP_GATE_MP 3.54939f
C506 ibias0 ota_cmfb_top_0.dynamic_pcell_5_0.G_DRN 9.15027f
C507 a_49868_27779# a_50132_27779# 0.02325f
C508 ota_cmfb_top_0.dynamic_pcell_5_0.H_DRN ota_cmfb_top_0.dynamic_pcell_5_0.SRC_NET_KL 8.30578f
C509 ota_cmfb_top_0.dynamic_pcell_5_0.L_GATE ota_cmfb_top_0.dynamic_pcell_5_0.SRC_NET_KL 0.5844f
C510 a_50924_27218# a_50924_27132# 0.01257f
C511 w_59515_33612# a_58930_34440# 0.01802f
C512 a_50396_27132# a_49868_27132# 0.01672f
C513 ota_cmfb_top_0.dynamic_pcell_5_0.DRN_NET_JL a_48812_27979# 0.0104f
C514 ota_cmfb_top_0.ota_cmfb_core_push_pull_output_stage_1/dynamic_pcell_4_0.SRC_NET_QP_GATE_KLQ ota_cmfb_top_0.ota_cmfb_core_push_pull_output_stage_1/dynamic_pcell_4_0.SRC_NET_IJ_GATE_DI 0.02434f
C515 vdd_1v2 a_50924_27979# 0.06808f
C516 slot5_wrapper_0.clk enable 0.23029f
C517 vdd_1v2 ota_cmfb_top_0.ota_cmfb_core_push_pull_output_stage_0/dynamic_pcell_4_0.DRN_NET_OP_GATE_MP 0.01946f
C518 ota_cmfb_top_0.dynamic_pcell_5_0.L_GATE ota_cmfb_top_0.dynamic_pcell_5_0.H_DRN 0.10515f
C519 ota_cmfb_top_0.dynamic_pcell_5_0.DRN_NET_IK_GATE_IJ enable 0.1398f
C520 ota_cmfb_top_0.ota_cmfb_core_push_pull_output_stage_0/dynamic_pcell_4_0.SRC_NET_ML ota_cmfb_top_0.ota_cmfb_core_push_pull_output_stage_0/dynamic_pcell_4_0.DRN_NET_MENX 2.93918f
C521 a_49604_27779# a_49868_27779# 0.02325f
C522 ota_cmfb_top_0.ota_cmfb_core_push_pull_output_stage_1/dynamic_pcell_4_0.DRN_NET_CD s5_an[2] 0.01639f
C523 a_48812_27779# a_49076_27779# 0.02325f
C524 ota_cmfb_top_0.dynamic_pcell_5_0.DRN_NET_BD ota_cmfb_top_0.ota_cmfb_core_push_pull_output_stage_0/dynamic_pcell_4_0.DRN_NET_J_GATE_EJ 0.88051f
C525 s5_an[1] a_52197_33717# 0.01822f
C526 ibias0 vss_1v2 96.6438f
C527 enable vss_1v2 20.1381f
C528 s5_an[0] vss_1v2 0.15667p
C529 analog_bus0 vss_1v2 15.5583f
C530 analog_bus1 vss_1v2 15.0652f
C531 s5_an[2] vss_1v2 41.00861f
C532 s5_an[1] vss_1v2 30.55557f
C533 vdd_1v2 vss_1v2 0.35124p
C534 slot5_wrapper_0.vss_3v3 vss_1v2 2.53718f
C535 slot5_wrapper_0.vdd_3v3 vss_1v2 8.76404f
C536 slot5_wrapper_0.s5_an_0_esd vss_1v2 0.15069f ; **FLOATING
C537 slot5_wrapper_0.dig_out[0] vss_1v2 0.13023f
C538 slot5_wrapper_0.dig_out[1] vss_1v2 0.04024f
C539 slot5_wrapper_0.dig_out[2] vss_1v2 0.04024f
C540 slot5_wrapper_0.dig_out[3] vss_1v2 0.04024f
C541 slot5_wrapper_0.dig_out[4] vss_1v2 0.04024f
C542 slot5_wrapper_0.dig_out[5] vss_1v2 0.04006f
C543 slot5_wrapper_0.dig_out[6] vss_1v2 0.04006f
C544 slot5_wrapper_0.dig_out[7] vss_1v2 0.04006f
C545 slot5_wrapper_0.dig_out[8] vss_1v2 0.04006f
C546 slot5_wrapper_0.dig_out[9] vss_1v2 0.04006f
C547 slot5_wrapper_0.dig_out[10] vss_1v2 0.04006f
C548 slot5_wrapper_0.dig_out[11] vss_1v2 0.05719f
C549 slot5_wrapper_0.dig_in[0] vss_1v2 0.05719f
C550 slot5_wrapper_0.dig_in[1] vss_1v2 0.04024f
C551 slot5_wrapper_0.dig_in[2] vss_1v2 0.04024f
C552 slot5_wrapper_0.dig_in[3] vss_1v2 0.04024f
C553 slot5_wrapper_0.dig_in[4] vss_1v2 0.04024f
C554 slot5_wrapper_0.dig_in[5] vss_1v2 0.04024f
C555 slot5_wrapper_0.dig_in[6] vss_1v2 0.04024f
C556 slot5_wrapper_0.dig_in[7] vss_1v2 0.04024f
C557 slot5_wrapper_0.dig_in[8] vss_1v2 0.04024f
C558 slot5_wrapper_0.dig_in[9] vss_1v2 0.04024f
C559 slot5_wrapper_0.dig_in[10] vss_1v2 0.04024f
C560 slot5_wrapper_0.dig_in[11] vss_1v2 0.04024f
C561 slot5_wrapper_0.dig_in[12] vss_1v2 0.04024f
C562 slot5_wrapper_0.dig_in[13] vss_1v2 0.04024f
C563 slot5_wrapper_0.dig_in[14] vss_1v2 0.04024f
C564 slot5_wrapper_0.dig_in[15] vss_1v2 0.04024f
C565 slot5_wrapper_0.dig_in[16] vss_1v2 0.04024f
C566 slot5_wrapper_0.dig_in[17] vss_1v2 0.04024f
C567 slot5_wrapper_0.dig_in[18] vss_1v2 0.04006f
C568 slot5_wrapper_0.dig_in[19] vss_1v2 0.04006f
C569 slot5_wrapper_0.dig_in[20] vss_1v2 0.04006f
C570 slot5_wrapper_0.dig_in[21] vss_1v2 0.04006f
C571 slot5_wrapper_0.dig_in[22] vss_1v2 0.04006f
C572 slot5_wrapper_0.dig_in[23] vss_1v2 0.04006f
C573 slot5_wrapper_0.reset vss_1v2 0.04026f
C574 slot5_wrapper_0.clk vss_1v2 0.09059f
C575 m3_0_18723# vss_1v2 0.09889f
C576 slot5_wrapper_0.vbias vss_1v2 0.29582f
C577 m3_0_19311# vss_1v2 0.03587f
C578 m3_0_19899# vss_1v2 0.03077f
C579 slot5_wrapper_0.ibias1 vss_1v2 0.18745f
C580 m3_0_20487# vss_1v2 0.02939f
C581 slot5_wrapper_0.analog_bus3 vss_1v2 0.18025f
C582 m3_0_21075# vss_1v2 0.02853f
C583 slot5_wrapper_0.analog_bus2 vss_1v2 0.17696f
C584 m3_0_21663# vss_1v2 0.02853f
C585 m3_0_22251# vss_1v2 0.02844f
C586 m3_0_22839# vss_1v2 0.08667f
C587 slot5_wrapper_0.s5_an_1_esd vss_1v2 0.15069f ; **FLOATING
C588 ota_cmfb_top_0.ota_cmfb_core_push_pull_output_stage_0/dynamic_pcell_4_0.SRC_NET_ML vss_1v2 4.1079f ; **FLOATING
C589 ota_cmfb_top_0.ota_cmfb_core_push_pull_output_stage_0/dynamic_pcell_4_0.DRN_NET_OP_GATE_MP vss_1v2 16.3026f ; **FLOATING
C590 ota_cmfb_top_0.ota_cmfb_core_push_pull_output_stage_0/dynamic_pcell_4_0.SRC_NET_QP_GATE_KLQ vss_1v2 26.2028f ; **FLOATING
C591 ota_cmfb_top_0.ota_cmfb_core_push_pull_output_stage_1/dynamic_pcell_4_0.SRC_NET_ML vss_1v2 4.06847f ; **FLOATING
C592 ota_cmfb_top_0.ota_cmfb_core_push_pull_output_stage_1/dynamic_pcell_4_0.DRN_NET_OP_GATE_MP vss_1v2 16.2921f ; **FLOATING
C593 ota_cmfb_top_0.ota_cmfb_core_push_pull_output_stage_1/dynamic_pcell_4_0.SRC_NET_QP_GATE_KLQ vss_1v2 26.1896f ; **FLOATING
C594 ota_cmfb_top_0.ota_cmfb_core_push_pull_output_stage_0/dynamic_pcell_4_0.DRN_NET_MENX vss_1v2 10.3085f ; **FLOATING
C595 ota_cmfb_top_0.ota_cmfb_core_push_pull_output_stage_0/dynamic_pcell_4_0.DRN_NET_HI vss_1v2 0.02898f ; **FLOATING
C596 ota_cmfb_top_0.ota_cmfb_core_push_pull_output_stage_0/dynamic_pcell_4_0.DRN_NET_J_GATE_EJ vss_1v2 3.85764f ; **FLOATING
C597 ota_cmfb_top_0.ota_cmfb_core_push_pull_output_stage_0/dynamic_pcell_4_0.DRN_NET_CD vss_1v2 0.02038f ; **FLOATING
C598 ota_cmfb_top_0.ota_cmfb_core_push_pull_output_stage_0/dynamic_pcell_4_0.B_DRN vss_1v2 11.6454f ; **FLOATING
C599 ota_cmfb_top_0.ota_cmfb_core_push_pull_output_stage_0/dynamic_pcell_4_0.SRC_NET_IJ_GATE_DI vss_1v2 0.17757f ; **FLOATING
C600 ota_cmfb_top_0.dynamic_pcell_5_0.F_DRN vss_1v2 5.05678f ; **FLOATING
C601 a_50924_27132# vss_1v2 0.35249f ; **FLOATING
C602 a_50660_27418# vss_1v2 0.28221f ; **FLOATING
C603 a_50396_27132# vss_1v2 0.33612f ; **FLOATING
C604 a_50132_27418# vss_1v2 0.28198f ; **FLOATING
C605 a_49868_27132# vss_1v2 0.33602f ; **FLOATING
C606 a_49604_27418# vss_1v2 0.28211f ; **FLOATING
C607 a_49340_27132# vss_1v2 0.33611f ; **FLOATING
C608 a_49076_27418# vss_1v2 0.28255f ; **FLOATING
C609 a_48812_27132# vss_1v2 0.3601f ; **FLOATING
C610 a_50924_27979# vss_1v2 0.28587f ; **FLOATING
C611 a_50660_27693# vss_1v2 0.27427f ; **FLOATING
C612 a_50396_27979# vss_1v2 0.27566f ; **FLOATING
C613 a_50132_27693# vss_1v2 0.27424f ; **FLOATING
C614 a_49868_27979# vss_1v2 0.27488f ; **FLOATING
C615 a_49604_27693# vss_1v2 0.27448f ; **FLOATING
C616 a_49340_27979# vss_1v2 0.2751f ; **FLOATING
C617 a_49076_27693# vss_1v2 0.27513f ; **FLOATING
C618 ota_cmfb_top_0.EN_INV_1/sg13cmos5l_inv_4_0.Y vss_1v2 0.65798f ; **FLOATING
C619 ota_cmfb_top_0.EN_INV_0/sg13cmos5l_inv_4_0.Y vss_1v2 0.64141f ; **FLOATING
C620 a_48812_27979# vss_1v2 0.29386f ; **FLOATING
C621 ota_cmfb_top_0.ota_cmfb_core_push_pull_output_stage_1/dynamic_pcell_4_0.DRN_NET_MENX vss_1v2 10.2673f ; **FLOATING
C622 ota_cmfb_top_0.ota_cmfb_core_push_pull_output_stage_1/dynamic_pcell_4_0.DRN_NET_HI vss_1v2 0.0122f ; **FLOATING
C623 ota_cmfb_top_0.ota_cmfb_core_push_pull_output_stage_1/dynamic_pcell_4_0.DRN_NET_J_GATE_EJ vss_1v2 2.24579f ; **FLOATING
C624 ota_cmfb_top_0.ota_cmfb_core_push_pull_output_stage_1/dynamic_pcell_4_0.DRN_NET_CD vss_1v2 0.0177f ; **FLOATING
C625 ota_cmfb_top_0.ota_cmfb_core_push_pull_output_stage_1/dynamic_pcell_4_0.B_DRN vss_1v2 11.3751f ; **FLOATING
C626 ota_cmfb_top_0.ota_cmfb_core_push_pull_output_stage_1/dynamic_pcell_4_0.SRC_NET_IJ_GATE_DI vss_1v2 0.07234f ; **FLOATING
C627 ota_cmfb_top_0.dynamic_pcell_5_0.G_DRN vss_1v2 3.85174f ; **FLOATING
C628 ota_cmfb_top_0.dynamic_pcell_5_0.DRN_NET_IK_GATE_IJ vss_1v2 34.3001f ; **FLOATING
C629 ota_cmfb_top_0.dynamic_pcell_5_0.DRN_NET_JL vss_1v2 6.41798f ; **FLOATING
C630 ota_cmfb_top_0.dynamic_pcell_5_0.SRC_NET_AB vss_1v2 0.44039f ; **FLOATING
C631 ota_cmfb_top_0.dynamic_pcell_5_0.L_GATE vss_1v2 0.9094f ; **FLOATING
C632 ota_cmfb_top_0.dynamic_pcell_5_0.DRN_NET_BD vss_1v2 7.67866f ; **FLOATING
C633 a_58930_33631# vss_1v2 0.30752f ; **FLOATING
C634 a_58666_33917# vss_1v2 0.27002f ; **FLOATING
C635 a_58402_33631# vss_1v2 0.32348f ; **FLOATING
C636 a_58930_34440# vss_1v2 0.33559f ; **FLOATING
C637 a_58666_34154# vss_1v2 0.27644f ; **FLOATING
C638 a_58402_33917# vss_1v2 0.32239f ; **FLOATING
C639 a_58402_34440# vss_1v2 0.3492f ; **FLOATING
C640 ota_cmfb_top_0.dynamic_pcell_5_0.DRN_NET_CA vss_1v2 8.59606f ; **FLOATING
C641 a_52197_33631# vss_1v2 0.30752f ; **FLOATING
C642 a_51933_33917# vss_1v2 0.27002f ; **FLOATING
C643 a_51669_33631# vss_1v2 0.32189f ; **FLOATING
C644 a_52197_34440# vss_1v2 0.33559f ; **FLOATING
C645 a_51933_34154# vss_1v2 0.27644f ; **FLOATING
C646 a_51669_33917# vss_1v2 0.32049f ; **FLOATING
C647 a_51669_34440# vss_1v2 0.34897f ; **FLOATING
C648 ota_cmfb_top_0.dynamic_pcell_5_0.SRC_NET_KL vss_1v2 0.58978f ; **FLOATING
C649 ota_cmfb_top_0.dynamic_pcell_5_0.H_DRN vss_1v2 5.66243f ; **FLOATING
C650 w_59515_33612# vss_1v2 0.94041f ; **FLOATING
C651 w_52782_33612# vss_1v2 0.93922f ; **FLOATING
.ends
