** sch_path: /run/media/yacinesot/My_Files/XschemDesigns/designs/Chipalooza2/schema/ota_cmfb_top_pex_tb.sch
**.subckt ota_cmfb_top_pex_tb
xprobe1 Vinp net10 Vinn net11 ac_diff_probe vcm={vcm_in} vac=1
Vmeas2 net5 net12 0
.save i(vmeas2)
Vmeas3 net6 net13 0
.save i(vmeas3)
Vmeas4 Voutp net11 0
.save i(vmeas4)
Vmeas5 Voutn net10 0
.save i(vmeas5)
R1 net14 Vinn 500k
R2 Vinn Vt_n 500k
R3 net15 Vinp 500k
R4 Vinp Vt_p 500k
X2 Voutn Vinn Vinp Ibias EN Voutp Vcm VDD VSS sg13cmos5l_yacinesot_ip__diff_opamp_cmfb
**** begin user architecture code

VSS VSS 0 0
VDD VDD VSS 1.5
VEN EN VSS 1.2
Vcm Vcm VSS {vcm}
Ibias VDD Ibias 2.5u

.control
op
let ro_n = voutn/i(vmeas2)
let ro_p = voutp/i(vmeas3)
print ro_n ro_p
write ota_cmfb_top_pex_tb.raw
.endc

.lib cornerMOSlv.lib mos_tt
.lib cornerMOShv.lib mos_tt
.lib cornerMOSCAP.lib moscap_tt
.lib cornerCAP.lib cap_typ
.lib cornerRES.lib res_typ
.lib cornerDIO.lib dio_tt

.control
ac dec 50 100 100G
let vout_diff = voutp-voutn
let vin_diff = vinp-vinn
let diff_gain=vout_diff/vin_diff
let op_mag=db(diff_gain)
let op_ph = 180*cph(diff_gain)/pi + 180
let vcm_1 = (voutp+voutn)/2
let vcm_err = mag((vcm_1 - {vcm}))[0]
echo results_save_begin
meas ac dc_gain find op_mag when frequency=1000
meas ac gain_margin find op_mag when op_ph=0
meas ac phase_margin find op_ph when op_mag=0
meas ac bw_3db find frequency when op_mag=dc_gain-3
meas ac Gain_BW find frequency when op_mag=0
print vcm_err
echo results_save_end
plot op_mag op_ph
.endc

.option rshunt=1e9
.options method=gear
.param vcm=0.75 vcm_in=0.75 cl=0.1p
.save all

CL1 Voutp 0 {cl}
CL2 Voutn 0 {cl}
RL1 Voutp 0 100k
RL2 Voutn 0 100k

.include ota_cmfb_top_pex_tb.save
.include /run/media/yacinesot/My_Files/XschemDesigns/designs/Chipalooza2/pex/slot_5.gds.spice

**nr_workers=1
**nr_mc_sims=100

**results_plot_begin
**dc_gain
**gain_margin
**phase_margin
**bw_3db
**Gain_BW
**vcm_err
**results_plot_end

**** end user architecture code
**.ends

* expanding   symbol:  ac_diff_probe/ac_diff_probe.sym # of pins=4
** sym_path: /run/media/yacinesot/My_Files/XschemDesigns/designs/Chipalooza2/schema/ac_diff_probe/ac_diff_probe.sym
** sch_path: /run/media/yacinesot/My_Files/XschemDesigns/designs/Chipalooza2/schema/ac_diff_probe/ac_diff_probe.sch
.subckt ac_diff_probe INP OUTN INN OUTP  vcm=0.75 vac=0.1
*.iopin OUTN
*.iopin INP
*.iopin OUTP
*.iopin INN
xprobe1 OUTN INP ac_probe vcm={vcm} vac={vac}
xprobe2 OUTP INN ac_probe vcm={vcm} vac=-{vac}
.ends

* expanding   symbol:  ac_probe/ac_probe.sym # of pins=2
** sym_path: /run/media/yacinesot/My_Files/XschemDesigns/designs/Chipalooza2/schema/ac_probe/ac_probe.sym
** sch_path: /run/media/yacinesot/My_Files/XschemDesigns/designs/Chipalooza2/schema/ac_probe/ac_probe.sch
.subckt ac_probe OUT IN  vcm=0.75 vac=0.01

*.iopin IN
*.iopin OUT
C1 0 IN 1
V1 IN 0 {vcm} ac {vac}
R1 OUT IN 1G
.ends

.end
