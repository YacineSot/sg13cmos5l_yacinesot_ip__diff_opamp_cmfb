** sch_path: /run/media/yacinesot/My_Files/XschemDesigns/designs/Chipalooza2/schema/ota_cmfb_top_pex_tb.sch
**.subckt ota_cmfb_top_pex_tb
Vmeas2 net5 net12 0
.save i(vmeas2)
Vmeas3 net6 net13 0
.save i(vmeas3)
Vmeas4 Voutp net11 0
.save i(vmeas4)
Vmeas5 Voutn net10 0
.save i(vmeas5)
R1 net14 Vinn 500k
R2 Vinn Vt_n 500k
R3 net15 Vinp 500k
R4 Vinp Vt_p 500k
X1 VDD VSS Ibias EN Vinp Vinn Vcm Voutn Voutp ota_cmfb_top
**** begin user architecture code

.control
op
write ota_cmfb_top_pex_tb.raw
.endc

.lib cornerMOSlv.lib mos_tt
.lib cornerMOShv.lib mos_tt
.lib cornerMOSCAP.lib moscap_tt
.lib cornerCAP.lib cap_typ
.lib cornerRES.lib res_typ
.lib cornerDIO.lib dio_tt

.option rshunt=1e9
.options method=gear
.param vcm=0.75 vcm_in=0.75 cl=0.1p vac=1
.save all

CL1 Voutp 0 {cl}
CL2 Voutn 0 {cl}
RL1 Voutp 0 100k
RL2 Voutn 0 100k

.include ota_cmfb_top_pex_tb.save

VSS VSS 0 0
VDD VDD VDD_AC 1.5
VDD_AC VDD_AC VSS 0 AC 0
VEN EN VSS 1.5
Vcm Vcm VSS {vcm}
Ibias VDD Ibias 2.5u

.include /run/media/yacinesot/My_Files/XschemDesigns/designs/Chipalooza2/pex/ota_cmfb_top.gds.spice

VICM  vicm  0  DC 0.75
VDIFF vdiff 0  DC 0 AC 1
EIP Vinp vicm vdiff 0  0.5
EIN Vinn vicm vdiff 0 -0.5
EOD vod 0 Voutp Voutn 1

.control
save all
noise v(vod) VDIFF dec 10 1 50Meg
run
noise v(vod) VDIFF dec 10 1 1000Meg
setplot noise3
plot loglog inoise_spectrum onoise_spectrum
echo results_save_begin
foreach freq 1 10 100 1k 10k 100k 1Meg
	let index = 0
  	while frequency[index] < $freq
    		let index = index + 1
  	end
	let noise_$freq = inoise_spectrum[$&index]
	let index = $&index + 1
	print noise_$freq
end
setplot noise2
print inoise_total
echo results_save_end
.endc

**nr_workers=1
**nr_mc_sims=100

**results_plot_begin
**noise_1
**noise_10
**noise_100
**noise_1k
**noise_10k
**noise_100k
**noise_1meg
**inoise_total
**results_plot_end

**** end user architecture code
**.ends

* expanding   symbol:  ac_diff_probe/ac_diff_probe.sym # of pins=4
** sym_path: /run/media/yacinesot/My_Files/XschemDesigns/designs/Chipalooza2/schema/ac_diff_probe/ac_diff_probe.sym
** sch_path: /run/media/yacinesot/My_Files/XschemDesigns/designs/Chipalooza2/schema/ac_diff_probe/ac_diff_probe.sch
.subckt ac_diff_probe INP OUTN INN OUTP  vcm=0.75 vac=0.1
*.iopin OUTN
*.iopin INP
*.iopin OUTP
*.iopin INN
xprobe1 OUTN INP ac_probe vcm={vcm} vac={vac}
xprobe2 OUTP INN ac_probe vcm={vcm} vac=-{vac}
.ends

* expanding   symbol:  ac_probe/ac_probe.sym # of pins=2
** sym_path: /run/media/yacinesot/My_Files/XschemDesigns/designs/Chipalooza2/schema/ac_probe/ac_probe.sym
** sch_path: /run/media/yacinesot/My_Files/XschemDesigns/designs/Chipalooza2/schema/ac_probe/ac_probe.sch
.subckt ac_probe OUT IN  vcm=0.75 vac=0.01

*.iopin IN
*.iopin OUT
C1 0 IN 1
V1 IN 0 {vcm} ac {vac}
R1 OUT IN 1G
.ends

.end
