.subckt ota_cmfb_top VDD VSS
.ends
.end
